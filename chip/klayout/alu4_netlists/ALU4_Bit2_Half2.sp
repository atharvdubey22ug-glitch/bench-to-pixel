* Spice output from KLayout SiEPIC-Tools v0.5.31, 2026-10-15 13:02:26.

.subckt EBeam_heaters_atharvdubey_ALU4 wg_heater_169_elec1 wg_heater_169_elec2 wg_heater_178_elec1 wg_heater_178_elec2 wg_heater_198_elec1 wg_heater_198_elec2 wg_heater_201_elec1 wg_heater_201_elec2 wg_heater_213_elec1 wg_heater_213_elec2 GC_TE_1550_8degOxide_BB_detector3 GC_TE_1550_8degOxide_BB_detector2 GC_TE_1550_8degOxide_BB_laser GC_TE_1550_8degOxide_BB_detector1
.param MC_uniformity_width=0
.param MC_uniformity_thickness=0
.param MC_resolution_x=100
.param MC_resolution_y=100
.param MC_grid=10e-6
.param MC_non_uniform=0
 ebeam_wg_integral_1550_112  N$124 N$125 ebeam_wg_integral_1550 library="Design kits/EBeam" wg_length=0.000124247 wg_width=5e-07 points="[[864.05,1881.65],[906.4,1881.65],[906.4,1839.0],[948.75,1839.0]]" radius=5e-06 lay_x=906.4E-6 lay_y=1.860325E-3 sch_x=26.261787009E0 sch_y=53.900550439E0
 ebeam_wg_integral_1550_113  N$126 N$127 ebeam_wg_integral_1550 library="Design kits/EBeam" wg_length=0.000640597 wg_width=5e-07 points="[[864.05,1886.35],[890.05,1886.35],[890.05,1944.0],[1450.1,1944.0]]" radius=5e-06 lay_x=1.157075E-3 lay_y=1.915175E-3 sch_x=33.524776262E0 sch_y=55.489759417E0
 ebeam_bdc_te1550_167  N$187 N$184 N$185 N$186 ebeam_bdc_te1550 library="Design kits/ebeam"  lay_x=475.975E-6 lay_y=1.75135E-3 sch_x=13.790770159E0 sch_y=50.743138436E0  sch_r=180
 ebeam_bdc_te1550_168  N$189 N$190 N$191 N$188 ebeam_bdc_te1550 library="Design kits/ebeam"  lay_x=235.375E-6 lay_y=1.75135E-3 sch_x=6.819691215E0 sch_y=50.743138436E0  sch_r=180
 wg_heater_169  wg_heater_169_elec1 wg_heater_169_elec2 N$192 N$193 wg_heater library="Design kits/EBeam" wg_length=120.000u lay_x=355.9E-6 lay_y=1.77135E-3 sch_x=10.311749776E0 sch_y=51.322612995E0  sch_r=180
 ebeam_terminator_te1550_170  N$184 ebeam_terminator_te1550 library="Design kits/ebeam"  lay_x=516.8E-6 lay_y=1.7537E-3 sch_x=14.973622602E0 sch_y=50.811226697E0  sch_r=180
 ebeam_terminator_te1550_171  N$188 ebeam_terminator_te1550 library="Design kits/ebeam"  lay_x=194.55E-6 lay_y=1.7537E-3 sch_x=5.636838772E0 sch_y=50.811226697E0
 ebeam_wg_integral_1550_172  N$185 N$189 ebeam_wg_integral_1550 library="Design kits/EBeam" wg_length=0.000198943 wg_width=5e-07 points="[[440.6,1749.0],[430.6,1749.0],[430.6,1731.35],[280.75,1731.35],[280.75,1749.0],[270.75,1749.0]]" radius=5e-06 lay_x=355.675E-6 lay_y=1.740175E-3 sch_x=10.305230687E0 sch_y=50.419357027E0
 ebeam_wg_integral_1550_173  N$186 N$192 ebeam_wg_integral_1550 library="Design kits/EBeam" wg_length=0.000039247 wg_width=5e-07 points="[[440.6,1753.7],[430.6,1753.7],[430.6,1771.35],[415.9,1771.35]]" radius=5e-06 lay_x=428.25E-6 lay_y=1.762525E-3 sch_x=12.407998992E0 sch_y=51.066919846E0
 ebeam_wg_integral_1550_174  N$193 N$190 ebeam_wg_integral_1550 library="Design kits/EBeam" wg_length=0.000039697 wg_width=5e-07 points="[[295.9,1771.35],[280.75,1771.35],[280.75,1753.7],[270.75,1753.7]]" radius=5e-06 lay_x=283.325E-6 lay_y=1.762525E-3 sch_x=8.20898147E0 sch_y=51.066919846E0
 ebeam_wg_integral_1550_175  N$194 N$191 ebeam_wg_integral_1550 library="Design kits/EBeam" wg_length=0.000080000 wg_width=5e-07 points="[[120.0,1749.0],[200.0,1749.0]]" radius=5e-06 lay_x=160.0E-6 lay_y=1.749E-3 sch_x=4.635796471E0 sch_y=50.675050176E0
 ebeam_bdc_te1550_176  N$198 N$195 N$196 N$197 ebeam_bdc_te1550 library="Design kits/ebeam"  lay_x=475.975E-6 lay_y=1.62435E-3 sch_x=13.790770159E0 sch_y=47.063474987E0  sch_r=180
 ebeam_bdc_te1550_177  N$200 N$201 N$202 N$199 ebeam_bdc_te1550 library="Design kits/ebeam"  lay_x=235.375E-6 lay_y=1.62435E-3 sch_x=6.819691215E0 sch_y=47.063474987E0  sch_r=180
 wg_heater_178  wg_heater_178_elec1 wg_heater_178_elec2 N$203 N$204 wg_heater library="Design kits/EBeam" wg_length=120.000u lay_x=355.9E-6 lay_y=1.64435E-3 sch_x=10.311749776E0 sch_y=47.642949546E0  sch_r=180
 ebeam_terminator_te1550_179  N$195 ebeam_terminator_te1550 library="Design kits/ebeam"  lay_x=516.8E-6 lay_y=1.6267E-3 sch_x=14.973622602E0 sch_y=47.131563248E0  sch_r=180
 ebeam_terminator_te1550_180  N$199 ebeam_terminator_te1550 library="Design kits/ebeam"  lay_x=194.55E-6 lay_y=1.6267E-3 sch_x=5.636838772E0 sch_y=47.131563248E0
 ebeam_wg_integral_1550_181  N$196 N$200 ebeam_wg_integral_1550 library="Design kits/EBeam" wg_length=0.000198943 wg_width=5e-07 points="[[440.6,1622.0],[430.6,1622.0],[430.6,1604.35],[280.75,1604.35],[280.75,1622.0],[270.75,1622.0]]" radius=5e-06 lay_x=355.675E-6 lay_y=1.613175E-3 sch_x=10.305230687E0 sch_y=46.739693578E0
 ebeam_wg_integral_1550_182  N$197 N$203 ebeam_wg_integral_1550 library="Design kits/EBeam" wg_length=0.000039247 wg_width=5e-07 points="[[440.6,1626.7],[430.6,1626.7],[430.6,1644.35],[415.9,1644.35]]" radius=5e-06 lay_x=428.25E-6 lay_y=1.635525E-3 sch_x=12.407998992E0 sch_y=47.387256397E0
 ebeam_wg_integral_1550_183  N$204 N$201 ebeam_wg_integral_1550 library="Design kits/EBeam" wg_length=0.000039697 wg_width=5e-07 points="[[295.9,1644.35],[280.75,1644.35],[280.75,1626.7],[270.75,1626.7]]" radius=5e-06 lay_x=283.325E-6 lay_y=1.635525E-3 sch_x=8.20898147E0 sch_y=47.387256397E0
 ebeam_wg_integral_1550_184  N$205 N$202 ebeam_wg_integral_1550 library="Design kits/EBeam" wg_length=0.000080000 wg_width=5e-07 points="[[120.0,1622.0],[200.0,1622.0]]" radius=5e-06 lay_x=160.0E-6 lay_y=1.622E-3 sch_x=4.635796471E0 sch_y=46.995386727E0
 ebeam_y_1550_185  N$206 N$208 N$207 ebeam_y_1550 library="Design kits/ebeam"  lay_x=581.35E-6 lay_y=1.816E-3 sch_x=16.843876741E0 sch_y=52.616289948E0
 ebeam_y_1550_186  N$209 N$211 N$210 ebeam_y_1550 library="Design kits/ebeam"  lay_x=671.35E-6 lay_y=1.81875E-3 sch_x=19.451512256E0 sch_y=52.6959677E0
 ebeam_wg_integral_1550_187  N$212 N$206 ebeam_wg_integral_1550 library="Design kits/EBeam" wg_length=0.000510847 wg_width=5e-07 points="[[120.0,1876.0],[543.95,1876.0],[543.95,1816.0],[573.95,1816.0]]" radius=5e-06 lay_x=346.975E-6 lay_y=1.846E-3 sch_x=10.053159254E0 sch_y=53.485501786E0
 ebeam_wg_integral_1550_188  N$207 N$187 ebeam_wg_integral_1550 library="Design kits/EBeam" wg_length=0.000158547 wg_width=5e-07 points="[[588.75,1813.25],[598.75,1813.25],[598.75,1749.0],[511.35,1749.0]]" radius=5e-06 lay_x=555.425E-6 lay_y=1.781125E-3 sch_x=16.092732844E0 sch_y=51.605831186E0
 ebeam_wg_integral_1550_189  N$208 N$209 ebeam_wg_integral_1550 library="Design kits/EBeam" wg_length=0.000075200 wg_width=5e-07 points="[[588.75,1818.75],[663.95,1818.75]]" radius=5e-06 lay_x=626.35E-6 lay_y=1.81875E-3 sch_x=18.147694498E0 sch_y=52.6959677E0
 ebeam_wg_integral_1550_190  N$210 N$198 ebeam_wg_integral_1550 library="Design kits/EBeam" wg_length=0.000378297 wg_width=5e-07 points="[[678.75,1816.0],[688.75,1816.0],[688.75,1622.0],[511.35,1622.0]]" radius=5e-06 lay_x=600.425E-6 lay_y=1.719E-3 sch_x=17.396550601E0 sch_y=49.805838337E0
 ebeam_bdc_te1550_191  N$213 N$214 N$124 N$126 ebeam_bdc_te1550 library="Design kits/ebeam"  lay_x=828.675E-6 lay_y=1.884E-3 sch_x=24.009804005E0 sch_y=54.586503448E0  sch_r=180 sch_f=true
 ebeam_wg_integral_1550_192  N$211 N$213 ebeam_wg_integral_1550 library="Design kits/EBeam" wg_length=0.000171597 wg_width=5e-07 points="[[678.75,1821.5],[753.3,1821.5],[753.3,1881.65],[793.3,1881.65]]" radius=5e-06 lay_x=736.025E-6 lay_y=1.851575E-3 sch_x=21.325388111E0 sch_y=53.64703032E0
 ebeam_wg_integral_1550_193  N$214 N$215 ebeam_wg_integral_1550 library="Design kits/EBeam" wg_length=0.000786847 wg_width=5e-07 points="[[793.3,1886.35],[781.3,1886.35],[781.3,2003.0],[120.0,2003.0]]" radius=5e-06 lay_x=456.65E-6 lay_y=1.944675E-3 sch_x=13.230852866E0 sch_y=56.344484391E0
 GC_TE_1550_8degOxide_BB_194  GC_TE_1550_8degOxide_BB_detector3 N$205 GC_TE_1550_8degOxide_BB library="Design kits/ebeam"  lay_x=100.015E-6 lay_y=1.622084E-3 sch_x=2.8978074E0 sch_y=46.99782052E0
 GC_TE_1550_8degOxide_BB_195  GC_TE_1550_8degOxide_BB_detector2 N$194 GC_TE_1550_8degOxide_BB library="Design kits/ebeam"  lay_x=100.015E-6 lay_y=1.749084E-3 sch_x=2.8978074E0 sch_y=50.677483969E0
 GC_TE_1550_8degOxide_BB_196  GC_TE_1550_8degOxide_BB_laser N$212 GC_TE_1550_8degOxide_BB library="Design kits/ebeam"  lay_x=100.015E-6 lay_y=1.876084E-3 sch_x=2.8978074E0 sch_y=54.357147418E0
 GC_TE_1550_8degOxide_BB_197  GC_TE_1550_8degOxide_BB_detector1 N$215 GC_TE_1550_8degOxide_BB library="Design kits/ebeam"  lay_x=100.015E-6 lay_y=2.003084E-3 sch_x=2.8978074E0 sch_y=58.036810867E0
 wg_heater_198  wg_heater_198_elec1 wg_heater_198_elec2 N$216 N$217 wg_heater library="Design kits/EBeam" wg_length=120.000u lay_x=1.3201E-3 lay_y=1.839E-3 sch_x=38.24821826E0 sch_y=53.282685691E0
 ebeam_bdc_te1550_199  N$127 N$218 N$219 N$220 ebeam_bdc_te1550 library="Design kits/ebeam"  lay_x=1.485475E-3 lay_y=1.94635E-3 sch_x=43.039748519E0 sch_y=56.393015386E0  sch_r=180 sch_f=true
 ebeam_bdc_te1550_200  N$222 N$223 N$224 N$221 ebeam_bdc_te1550 library="Design kits/ebeam"  lay_x=1.726075E-3 lay_y=1.94635E-3 sch_x=50.010827463E0 sch_y=56.393015386E0  sch_r=180 sch_f=true
 wg_heater_201  wg_heater_201_elec1 wg_heater_201_elec2 N$225 N$226 wg_heater library="Design kits/EBeam" wg_length=120.000u lay_x=1.60555E-3 lay_y=1.96635E-3 sch_x=46.518768902E0 sch_y=56.972489945E0  sch_r=180 sch_f=true
 ebeam_terminator_te1550_202  N$218 ebeam_terminator_te1550 library="Design kits/ebeam"  lay_x=1.44465E-3 lay_y=1.9487E-3 sch_x=41.856896076E0 sch_y=56.461103646E0  sch_r=180 sch_f=true
 ebeam_terminator_te1550_203  N$221 ebeam_terminator_te1550 library="Design kits/ebeam"  lay_x=1.7669E-3 lay_y=1.9487E-3 sch_x=51.193679906E0 sch_y=56.461103646E0  sch_f=true
 ebeam_wg_integral_1550_204  N$219 N$222 ebeam_wg_integral_1550 library="Design kits/EBeam" wg_length=0.000198943 wg_width=5e-07 points="[[1520.85,1944.0],[1530.85,1944.0],[1530.85,1926.35],[1680.7,1926.35],[1680.7,1944.0],[1690.7,1944.0]]" radius=5e-06 lay_x=1.605775E-3 lay_y=1.935175E-3 sch_x=46.525287991E0 sch_y=56.069233976E0
 ebeam_wg_integral_1550_205  N$220 N$225 ebeam_wg_integral_1550 library="Design kits/EBeam" wg_length=0.000039247 wg_width=5e-07 points="[[1520.85,1948.7],[1530.85,1948.7],[1530.85,1966.35],[1545.55,1966.35]]" radius=5e-06 lay_x=1.5332E-3 lay_y=1.957525E-3 sch_x=44.422519685E0 sch_y=56.716796795E0
 ebeam_wg_integral_1550_206  N$226 N$223 ebeam_wg_integral_1550 library="Design kits/EBeam" wg_length=0.000039697 wg_width=5e-07 points="[[1665.55,1966.35],[1680.7,1966.35],[1680.7,1948.7],[1690.7,1948.7]]" radius=5e-06 lay_x=1.678125E-3 lay_y=1.957525E-3 sch_x=48.621537208E0 sch_y=56.716796795E0
 ebeam_bdc_te1550_207  N$228 N$229 N$216 N$227 ebeam_bdc_te1550 library="Design kits/ebeam"  lay_x=1.224725E-3 lay_y=1.84135E-3 sch_x=35.484848957E0 sch_y=53.350773951E0  sch_r=180 sch_f=true
 ebeam_y_1550_208  N$224 N$230 N$231 ebeam_y_1550 library="Design kits/ebeam"  lay_x=1.76885E-3 lay_y=1.944E-3 sch_x=51.250178675E0 sch_y=56.324927125E0
 ebeam_wg_integral_1550_209  N$230 N$231 ebeam_wg_integral_1550 library="Design kits/EBeam" wg_length=0.000120390 wg_width=5e-07 points="[[1776.25,1946.75],[1788.85,1946.75],[1788.85,1959.0],[1813.85,1959.0],[1813.85,1929.0],[1788.85,1929.0],[1788.85,1941.25],[1776.25,1941.25]]" radius=5e-06 lay_x=1.795425E-3 lay_y=1.944E-3 sch_x=52.020155496E0 sch_y=56.324927125E0
 ebeam_wg_integral_1550_210  N$217 N$232 ebeam_wg_integral_1550 library="Design kits/EBeam" wg_length=0.000396350 wg_width=5e-07 points="[[1380.1,1839.0],[1776.45,1839.0]]" radius=5e-06 lay_x=1.578275E-3 lay_y=1.839E-3 sch_x=45.728510472E0 sch_y=53.282685691E0
 ebeam_y_1550_211  N$232 N$233 N$234 ebeam_y_1550 library="Design kits/ebeam"  lay_x=1.78385E-3 lay_y=1.839E-3 sch_x=51.684784595E0 sch_y=53.282685691E0
 ebeam_wg_integral_1550_212  N$233 N$234 ebeam_wg_integral_1550 library="Design kits/EBeam" wg_length=0.000120390 wg_width=5e-07 points="[[1791.25,1841.75],[1803.85,1841.75],[1803.85,1854.0],[1828.85,1854.0],[1828.85,1824.0],[1803.85,1824.0],[1803.85,1836.25],[1791.25,1836.25]]" radius=5e-06 lay_x=1.810425E-3 lay_y=1.839E-3 sch_x=52.454761415E0 sch_y=53.282685691E0
 wg_heater_213  wg_heater_213_elec1 wg_heater_213_elec2 N$235 N$236 wg_heater library="Design kits/EBeam" wg_length=120.000u lay_x=1.1042E-3 lay_y=1.86135E-3 sch_x=31.992790397E0 sch_y=53.93024851E0  sch_r=180 sch_f=true
 ebeam_terminator_te1550_214  N$237 ebeam_terminator_te1550 library="Design kits/ebeam"  lay_x=943.3E-6 lay_y=1.8437E-3 sch_x=27.33091757E0 sch_y=53.418862212E0  sch_r=180 sch_f=true
 ebeam_terminator_te1550_215  N$227 ebeam_terminator_te1550 library="Design kits/ebeam"  lay_x=1.26555E-3 lay_y=1.8437E-3 sch_x=36.667701401E0 sch_y=53.418862212E0  sch_f=true
 ebeam_wg_integral_1550_216  N$238 N$228 ebeam_wg_integral_1550 library="Design kits/EBeam" wg_length=0.000198943 wg_width=5e-07 points="[[1019.5,1839.0],[1029.5,1839.0],[1029.5,1821.35],[1179.35,1821.35],[1179.35,1839.0],[1189.35,1839.0]]" radius=5e-06 lay_x=1.104425E-3 lay_y=1.830175E-3 sch_x=31.999309486E0 sch_y=53.026992542E0
 ebeam_wg_integral_1550_217  N$239 N$235 ebeam_wg_integral_1550 library="Design kits/EBeam" wg_length=0.000039247 wg_width=5e-07 points="[[1019.5,1843.7],[1029.5,1843.7],[1029.5,1861.35],[1044.2,1861.35]]" radius=5e-06 lay_x=1.03185E-3 lay_y=1.852525E-3 sch_x=29.89654118E0 sch_y=53.674555361E0
 ebeam_wg_integral_1550_218  N$236 N$229 ebeam_wg_integral_1550 library="Design kits/EBeam" wg_length=0.000039697 wg_width=5e-07 points="[[1164.2,1861.35],[1179.35,1861.35],[1179.35,1843.7],[1189.35,1843.7]]" radius=5e-06 lay_x=1.176775E-3 lay_y=1.852525E-3 sch_x=34.095558702E0 sch_y=53.674555361E0
 ebeam_bdc_te1550_219  N$125 N$237 N$238 N$239 ebeam_bdc_te1550 library="Design kits/ebeam"  lay_x=984.125E-6 lay_y=1.84135E-3 sch_x=28.513770014E0 sch_y=53.350773951E0  sch_r=180 sch_f=true
.ends EBeam_heaters_atharvdubey_ALU4

EBeam_heaters_atharvdubey_ALU4  wg_heater_169_elec1 wg_heater_169_elec2 wg_heater_178_elec1 wg_heater_178_elec2 wg_heater_198_elec1 wg_heater_198_elec2 wg_heater_201_elec1 wg_heater_201_elec2 wg_heater_213_elec1 wg_heater_213_elec2  GC_TE_1550_8degOxide_BB_detector3 GC_TE_1550_8degOxide_BB_detector2 GC_TE_1550_8degOxide_BB_laser GC_TE_1550_8degOxide_BB_detector1 EBeam_heaters_atharvdubey_ALU4 sch_x=-1 sch_y=-1 sch_r=270
