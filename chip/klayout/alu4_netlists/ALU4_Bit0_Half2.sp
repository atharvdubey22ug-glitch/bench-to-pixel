* Spice output from KLayout SiEPIC-Tools v0.5.31, 2026-10-15 13:02:24.

.subckt EBeam_heaters_atharvdubey_ALU4 wg_heater_285_elec1 wg_heater_285_elec2 wg_heater_294_elec1 wg_heater_294_elec2 wg_heater_314_elec1 wg_heater_314_elec2 wg_heater_317_elec1 wg_heater_317_elec2 wg_heater_329_elec1 wg_heater_329_elec2 GC_TE_1550_8degOxide_BB_detector2 GC_TE_1550_8degOxide_BB_laser GC_TE_1550_8degOxide_BB_detector1 GC_TE_1550_8degOxide_BB_detector3
.param MC_uniformity_width=0
.param MC_uniformity_thickness=0
.param MC_resolution_x=100
.param MC_resolution_y=100
.param MC_grid=10e-6
.param MC_non_uniform=0
 ebeam_wg_integral_1550_222  N$244 N$245 ebeam_wg_integral_1550 library="Design kits/EBeam" wg_length=0.000124247 wg_width=5e-07 points="[[864.05,357.65],[906.4,357.65],[906.4,315.0],[948.75,315.0]]" radius=5e-06 lay_x=906.4E-6 lay_y=336.325E-6 sch_x=26.261787009E0 sch_y=9.744589051E0
 ebeam_wg_integral_1550_223  N$246 N$247 ebeam_wg_integral_1550 library="Design kits/EBeam" wg_length=0.000640597 wg_width=5e-07 points="[[864.05,362.35],[890.05,362.35],[890.05,420.0],[1450.1,420.0]]" radius=5e-06 lay_x=1.157075E-3 lay_y=391.175E-6 sch_x=33.524776262E0 sch_y=11.333798029E0
 GC_TE_1550_8degOxide_BB_280  GC_TE_1550_8degOxide_BB_detector2 N$306 GC_TE_1550_8degOxide_BB library="Design kits/ebeam"  lay_x=100.015E-6 lay_y=225.084E-6 sch_x=2.8978074E0 sch_y=6.521522581E0
 GC_TE_1550_8degOxide_BB_281  GC_TE_1550_8degOxide_BB_laser N$307 GC_TE_1550_8degOxide_BB library="Design kits/ebeam"  lay_x=100.015E-6 lay_y=352.084E-6 sch_x=2.8978074E0 sch_y=10.20118603E0
 GC_TE_1550_8degOxide_BB_282  GC_TE_1550_8degOxide_BB_detector1 N$308 GC_TE_1550_8degOxide_BB library="Design kits/ebeam"  lay_x=100.015E-6 lay_y=479.084E-6 sch_x=2.8978074E0 sch_y=13.880849479E0
 ebeam_bdc_te1550_283  N$312 N$309 N$310 N$311 ebeam_bdc_te1550 library="Design kits/ebeam"  lay_x=475.975E-6 lay_y=227.35E-6 sch_x=13.790770159E0 sch_y=6.587177048E0  sch_r=180
 ebeam_bdc_te1550_284  N$314 N$315 N$316 N$313 ebeam_bdc_te1550 library="Design kits/ebeam"  lay_x=235.375E-6 lay_y=227.35E-6 sch_x=6.819691215E0 sch_y=6.587177048E0  sch_r=180
 wg_heater_285  wg_heater_285_elec1 wg_heater_285_elec2 N$317 N$318 wg_heater library="Design kits/EBeam" wg_length=120.000u lay_x=355.9E-6 lay_y=247.35E-6 sch_x=10.311749776E0 sch_y=7.166651607E0  sch_r=180
 ebeam_terminator_te1550_286  N$309 ebeam_terminator_te1550 library="Design kits/ebeam"  lay_x=516.8E-6 lay_y=229.7E-6 sch_x=14.973622602E0 sch_y=6.655265309E0  sch_r=180
 ebeam_terminator_te1550_287  N$313 ebeam_terminator_te1550 library="Design kits/ebeam"  lay_x=194.55E-6 lay_y=229.7E-6 sch_x=5.636838772E0 sch_y=6.655265309E0
 ebeam_wg_integral_1550_288  N$310 N$314 ebeam_wg_integral_1550 library="Design kits/EBeam" wg_length=0.000198943 wg_width=5e-07 points="[[440.6,225.0],[430.6,225.0],[430.6,207.35],[280.75,207.35],[280.75,225.0],[270.75,225.0]]" radius=5e-06 lay_x=355.675E-6 lay_y=216.175E-6 sch_x=10.305230687E0 sch_y=6.263395638E0
 ebeam_wg_integral_1550_289  N$311 N$317 ebeam_wg_integral_1550 library="Design kits/EBeam" wg_length=0.000039247 wg_width=5e-07 points="[[440.6,229.7],[430.6,229.7],[430.6,247.35],[415.9,247.35]]" radius=5e-06 lay_x=428.25E-6 lay_y=238.525E-6 sch_x=12.407998992E0 sch_y=6.910958458E0
 ebeam_wg_integral_1550_290  N$318 N$315 ebeam_wg_integral_1550 library="Design kits/EBeam" wg_length=0.000039697 wg_width=5e-07 points="[[295.9,247.35],[280.75,247.35],[280.75,229.7],[270.75,229.7]]" radius=5e-06 lay_x=283.325E-6 lay_y=238.525E-6 sch_x=8.20898147E0 sch_y=6.910958458E0
 ebeam_wg_integral_1550_291  N$306 N$316 ebeam_wg_integral_1550 library="Design kits/EBeam" wg_length=0.000080000 wg_width=5e-07 points="[[120.0,225.0],[200.0,225.0]]" radius=5e-06 lay_x=160.0E-6 lay_y=225.0E-6 sch_x=4.635796471E0 sch_y=6.519088788E0
 ebeam_bdc_te1550_292  N$322 N$319 N$320 N$321 ebeam_bdc_te1550 library="Design kits/ebeam"  lay_x=475.975E-6 lay_y=100.35E-6 sch_x=13.790770159E0 sch_y=2.907513599E0  sch_r=180
 ebeam_bdc_te1550_293  N$324 N$325 N$326 N$323 ebeam_bdc_te1550 library="Design kits/ebeam"  lay_x=235.375E-6 lay_y=100.35E-6 sch_x=6.819691215E0 sch_y=2.907513599E0  sch_r=180
 wg_heater_294  wg_heater_294_elec1 wg_heater_294_elec2 N$327 N$328 wg_heater library="Design kits/EBeam" wg_length=120.000u lay_x=355.9E-6 lay_y=120.35E-6 sch_x=10.311749776E0 sch_y=3.486988158E0  sch_r=180
 ebeam_terminator_te1550_295  N$319 ebeam_terminator_te1550 library="Design kits/ebeam"  lay_x=516.8E-6 lay_y=102.7E-6 sch_x=14.973622602E0 sch_y=2.97560186E0  sch_r=180
 ebeam_terminator_te1550_296  N$323 ebeam_terminator_te1550 library="Design kits/ebeam"  lay_x=194.55E-6 lay_y=102.7E-6 sch_x=5.636838772E0 sch_y=2.97560186E0
 ebeam_wg_integral_1550_297  N$320 N$324 ebeam_wg_integral_1550 library="Design kits/EBeam" wg_length=0.000198943 wg_width=5e-07 points="[[440.6,98.0],[430.6,98.0],[430.6,80.35],[280.75,80.35],[280.75,98.0],[270.75,98.0]]" radius=5e-06 lay_x=355.675E-6 lay_y=89.175E-6 sch_x=10.305230687E0 sch_y=2.583732189E0
 ebeam_wg_integral_1550_298  N$321 N$327 ebeam_wg_integral_1550 library="Design kits/EBeam" wg_length=0.000039247 wg_width=5e-07 points="[[440.6,102.7],[430.6,102.7],[430.6,120.35],[415.9,120.35]]" radius=5e-06 lay_x=428.25E-6 lay_y=111.525E-6 sch_x=12.407998992E0 sch_y=3.231295009E0
 ebeam_wg_integral_1550_299  N$328 N$325 ebeam_wg_integral_1550 library="Design kits/EBeam" wg_length=0.000039697 wg_width=5e-07 points="[[295.9,120.35],[280.75,120.35],[280.75,102.7],[270.75,102.7]]" radius=5e-06 lay_x=283.325E-6 lay_y=111.525E-6 sch_x=8.20898147E0 sch_y=3.231295009E0
 ebeam_wg_integral_1550_300  N$329 N$326 ebeam_wg_integral_1550 library="Design kits/EBeam" wg_length=0.000080000 wg_width=5e-07 points="[[120.0,98.0],[200.0,98.0]]" radius=5e-06 lay_x=160.0E-6 lay_y=98.0E-6 sch_x=4.635796471E0 sch_y=2.839425339E0
 ebeam_y_1550_301  N$330 N$332 N$331 ebeam_y_1550 library="Design kits/ebeam"  lay_x=581.35E-6 lay_y=292.0E-6 sch_x=16.843876741E0 sch_y=8.46032856E0
 ebeam_y_1550_302  N$333 N$335 N$334 ebeam_y_1550 library="Design kits/ebeam"  lay_x=671.35E-6 lay_y=294.75E-6 sch_x=19.451512256E0 sch_y=8.540006312E0
 ebeam_wg_integral_1550_303  N$307 N$330 ebeam_wg_integral_1550 library="Design kits/EBeam" wg_length=0.000510847 wg_width=5e-07 points="[[120.0,352.0],[543.95,352.0],[543.95,292.0],[573.95,292.0]]" radius=5e-06 lay_x=346.975E-6 lay_y=322.0E-6 sch_x=10.053159254E0 sch_y=9.329540398E0
 ebeam_wg_integral_1550_304  N$331 N$312 ebeam_wg_integral_1550 library="Design kits/EBeam" wg_length=0.000158547 wg_width=5e-07 points="[[588.75,289.25],[598.75,289.25],[598.75,225.0],[511.35,225.0]]" radius=5e-06 lay_x=555.425E-6 lay_y=257.125E-6 sch_x=16.092732844E0 sch_y=7.449869798E0
 ebeam_wg_integral_1550_305  N$332 N$333 ebeam_wg_integral_1550 library="Design kits/EBeam" wg_length=0.000075200 wg_width=5e-07 points="[[588.75,294.75],[663.95,294.75]]" radius=5e-06 lay_x=626.35E-6 lay_y=294.75E-6 sch_x=18.147694498E0 sch_y=8.540006312E0
 ebeam_wg_integral_1550_306  N$334 N$322 ebeam_wg_integral_1550 library="Design kits/EBeam" wg_length=0.000378297 wg_width=5e-07 points="[[678.75,292.0],[688.75,292.0],[688.75,98.0],[511.35,98.0]]" radius=5e-06 lay_x=600.425E-6 lay_y=195.0E-6 sch_x=17.396550601E0 sch_y=5.649876949E0
 ebeam_bdc_te1550_307  N$336 N$337 N$244 N$246 ebeam_bdc_te1550 library="Design kits/ebeam"  lay_x=828.675E-6 lay_y=360.0E-6 sch_x=24.009804005E0 sch_y=10.43054206E0  sch_r=180 sch_f=true
 ebeam_wg_integral_1550_308  N$335 N$336 ebeam_wg_integral_1550 library="Design kits/EBeam" wg_length=0.000171597 wg_width=5e-07 points="[[678.75,297.5],[753.3,297.5],[753.3,357.65],[793.3,357.65]]" radius=5e-06 lay_x=736.025E-6 lay_y=327.575E-6 sch_x=21.325388111E0 sch_y=9.491068932E0
 ebeam_wg_integral_1550_309  N$337 N$308 ebeam_wg_integral_1550 library="Design kits/EBeam" wg_length=0.000786847 wg_width=5e-07 points="[[793.3,362.35],[781.3,362.35],[781.3,479.0],[120.0,479.0]]" radius=5e-06 lay_x=456.65E-6 lay_y=420.675E-6 sch_x=13.230852866E0 sch_y=12.188523003E0
 GC_TE_1550_8degOxide_BB_310  GC_TE_1550_8degOxide_BB_detector3 N$329 GC_TE_1550_8degOxide_BB library="Design kits/ebeam"  lay_x=100.015E-6 lay_y=98.084E-6 sch_x=2.8978074E0 sch_y=2.841859132E0
 ebeam_wg_integral_1550_311  N$338 N$339 ebeam_wg_integral_1550 library="Design kits/EBeam" wg_length=0.000039247 wg_width=5e-07 points="[[1019.5,319.7],[1029.5,319.7],[1029.5,337.35],[1044.2,337.35]]" radius=5e-06 lay_x=1.03185E-3 lay_y=328.525E-6 sch_x=29.89654118E0 sch_y=9.518593973E0
 ebeam_wg_integral_1550_312  N$341 N$340 ebeam_wg_integral_1550 library="Design kits/EBeam" wg_length=0.000039697 wg_width=5e-07 points="[[1164.2,337.35],[1179.35,337.35],[1179.35,319.7],[1189.35,319.7]]" radius=5e-06 lay_x=1.176775E-3 lay_y=328.525E-6 sch_x=34.095558702E0 sch_y=9.518593973E0
 ebeam_bdc_te1550_313  N$245 N$342 N$343 N$338 ebeam_bdc_te1550 library="Design kits/ebeam"  lay_x=984.125E-6 lay_y=317.35E-6 sch_x=28.513770014E0 sch_y=9.194812563E0  sch_r=180 sch_f=true
 wg_heater_314  wg_heater_314_elec1 wg_heater_314_elec2 N$344 N$345 wg_heater library="Design kits/EBeam" wg_length=120.000u lay_x=1.3201E-3 lay_y=315.0E-6 sch_x=38.24821826E0 sch_y=9.126724303E0
 ebeam_bdc_te1550_315  N$247 N$346 N$347 N$348 ebeam_bdc_te1550 library="Design kits/ebeam"  lay_x=1.485475E-3 lay_y=422.35E-6 sch_x=43.039748519E0 sch_y=12.237053998E0  sch_r=180 sch_f=true
 ebeam_bdc_te1550_316  N$350 N$351 N$352 N$349 ebeam_bdc_te1550 library="Design kits/ebeam"  lay_x=1.726075E-3 lay_y=422.35E-6 sch_x=50.010827463E0 sch_y=12.237053998E0  sch_r=180 sch_f=true
 wg_heater_317  wg_heater_317_elec1 wg_heater_317_elec2 N$353 N$354 wg_heater library="Design kits/EBeam" wg_length=120.000u lay_x=1.60555E-3 lay_y=442.35E-6 sch_x=46.518768902E0 sch_y=12.816528556E0  sch_r=180 sch_f=true
 ebeam_terminator_te1550_318  N$346 ebeam_terminator_te1550 library="Design kits/ebeam"  lay_x=1.44465E-3 lay_y=424.7E-6 sch_x=41.856896076E0 sch_y=12.305142258E0  sch_r=180 sch_f=true
 ebeam_terminator_te1550_319  N$349 ebeam_terminator_te1550 library="Design kits/ebeam"  lay_x=1.7669E-3 lay_y=424.7E-6 sch_x=51.193679906E0 sch_y=12.305142258E0  sch_f=true
 ebeam_wg_integral_1550_320  N$347 N$350 ebeam_wg_integral_1550 library="Design kits/EBeam" wg_length=0.000198943 wg_width=5e-07 points="[[1520.85,420.0],[1530.85,420.0],[1530.85,402.35],[1680.7,402.35],[1680.7,420.0],[1690.7,420.0]]" radius=5e-06 lay_x=1.605775E-3 lay_y=411.175E-6 sch_x=46.525287991E0 sch_y=11.913272588E0
 ebeam_wg_integral_1550_321  N$348 N$353 ebeam_wg_integral_1550 library="Design kits/EBeam" wg_length=0.000039247 wg_width=5e-07 points="[[1520.85,424.7],[1530.85,424.7],[1530.85,442.35],[1545.55,442.35]]" radius=5e-06 lay_x=1.5332E-3 lay_y=433.525E-6 sch_x=44.422519685E0 sch_y=12.560835407E0
 ebeam_wg_integral_1550_322  N$354 N$351 ebeam_wg_integral_1550 library="Design kits/EBeam" wg_length=0.000039697 wg_width=5e-07 points="[[1665.55,442.35],[1680.7,442.35],[1680.7,424.7],[1690.7,424.7]]" radius=5e-06 lay_x=1.678125E-3 lay_y=433.525E-6 sch_x=48.621537208E0 sch_y=12.560835407E0
 ebeam_bdc_te1550_323  N$356 N$340 N$344 N$355 ebeam_bdc_te1550 library="Design kits/ebeam"  lay_x=1.224725E-3 lay_y=317.35E-6 sch_x=35.484848957E0 sch_y=9.194812563E0  sch_r=180 sch_f=true
 ebeam_y_1550_324  N$352 N$357 N$358 ebeam_y_1550 library="Design kits/ebeam"  lay_x=1.76885E-3 lay_y=420.0E-6 sch_x=51.250178675E0 sch_y=12.168965737E0
 ebeam_wg_integral_1550_325  N$357 N$358 ebeam_wg_integral_1550 library="Design kits/EBeam" wg_length=0.000120390 wg_width=5e-07 points="[[1776.25,422.75],[1788.85,422.75],[1788.85,435.0],[1813.85,435.0],[1813.85,405.0],[1788.85,405.0],[1788.85,417.25],[1776.25,417.25]]" radius=5e-06 lay_x=1.795425E-3 lay_y=420.0E-6 sch_x=52.020155496E0 sch_y=12.168965737E0
 ebeam_wg_integral_1550_326  N$345 N$359 ebeam_wg_integral_1550 library="Design kits/EBeam" wg_length=0.000396350 wg_width=5e-07 points="[[1380.1,315.0],[1776.45,315.0]]" radius=5e-06 lay_x=1.578275E-3 lay_y=315.0E-6 sch_x=45.728510472E0 sch_y=9.126724303E0
 ebeam_y_1550_327  N$359 N$360 N$361 ebeam_y_1550 library="Design kits/ebeam"  lay_x=1.78385E-3 lay_y=315.0E-6 sch_x=51.684784595E0 sch_y=9.126724303E0
 ebeam_wg_integral_1550_328  N$360 N$361 ebeam_wg_integral_1550 library="Design kits/EBeam" wg_length=0.000120390 wg_width=5e-07 points="[[1791.25,317.75],[1803.85,317.75],[1803.85,330.0],[1828.85,330.0],[1828.85,300.0],[1803.85,300.0],[1803.85,312.25],[1791.25,312.25]]" radius=5e-06 lay_x=1.810425E-3 lay_y=315.0E-6 sch_x=52.454761415E0 sch_y=9.126724303E0
 wg_heater_329  wg_heater_329_elec1 wg_heater_329_elec2 N$339 N$341 wg_heater library="Design kits/EBeam" wg_length=120.000u lay_x=1.1042E-3 lay_y=337.35E-6 sch_x=31.992790397E0 sch_y=9.774287122E0  sch_r=180 sch_f=true
 ebeam_terminator_te1550_330  N$342 ebeam_terminator_te1550 library="Design kits/ebeam"  lay_x=943.3E-6 lay_y=319.7E-6 sch_x=27.33091757E0 sch_y=9.262900824E0  sch_r=180 sch_f=true
 ebeam_terminator_te1550_331  N$355 ebeam_terminator_te1550 library="Design kits/ebeam"  lay_x=1.26555E-3 lay_y=319.7E-6 sch_x=36.667701401E0 sch_y=9.262900824E0  sch_f=true
 ebeam_wg_integral_1550_332  N$343 N$356 ebeam_wg_integral_1550 library="Design kits/EBeam" wg_length=0.000198943 wg_width=5e-07 points="[[1019.5,315.0],[1029.5,315.0],[1029.5,297.35],[1179.35,297.35],[1179.35,315.0],[1189.35,315.0]]" radius=5e-06 lay_x=1.104425E-3 lay_y=306.175E-6 sch_x=31.999309486E0 sch_y=8.871031154E0
.ends EBeam_heaters_atharvdubey_ALU4

EBeam_heaters_atharvdubey_ALU4  wg_heater_285_elec1 wg_heater_285_elec2 wg_heater_294_elec1 wg_heater_294_elec2 wg_heater_314_elec1 wg_heater_314_elec2 wg_heater_317_elec1 wg_heater_317_elec2 wg_heater_329_elec1 wg_heater_329_elec2  GC_TE_1550_8degOxide_BB_detector2 GC_TE_1550_8degOxide_BB_laser GC_TE_1550_8degOxide_BB_detector1 GC_TE_1550_8degOxide_BB_detector3 EBeam_heaters_atharvdubey_ALU4 sch_x=-1 sch_y=-1 sch_r=270
