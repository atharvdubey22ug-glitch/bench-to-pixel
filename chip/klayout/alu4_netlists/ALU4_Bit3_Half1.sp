* Spice output from KLayout SiEPIC-Tools v0.5.31, 2026-10-15 13:02:26.

.subckt EBeam_heaters_atharvdubey_ALU4 wg_heater_7_elec1 wg_heater_7_elec2 wg_heater_10_elec1 wg_heater_10_elec2 wg_heater_16_elec1 wg_heater_16_elec2 wg_heater_33_elec1 wg_heater_33_elec2 wg_heater_42_elec1 wg_heater_42_elec2 GC_TE_1550_8degOxide_BB_detector2 GC_TE_1550_8degOxide_BB_laser GC_TE_1550_8degOxide_BB_detector1 GC_TE_1550_8degOxide_BB_detector3
.param MC_uniformity_width=0
.param MC_uniformity_thickness=0
.param MC_resolution_x=100
.param MC_resolution_y=100
.param MC_grid=10e-6
.param MC_non_uniform=0
 ebeam_terminator_te1550_0  N$0 ebeam_terminator_te1550 library="Design kits/ebeam"  lay_x=2.7933E-3 lay_y=2.6057E-3 sch_x=80.932314269E0 sch_y=75.496842906E0  sch_r=180 sch_f=true
 ebeam_wg_integral_1550_1  N$2 N$1 ebeam_wg_integral_1550 library="Design kits/EBeam" wg_length=0.000124247 wg_width=5e-07 points="[[2714.05,2643.65],[2756.4,2643.65],[2756.4,2601.0],[2798.75,2601.0]]" radius=5e-06 lay_x=2.7564E-3 lay_y=2.622325E-3 sch_x=79.863183707E0 sch_y=75.978531133E0
 ebeam_wg_integral_1550_2  N$4 N$3 ebeam_wg_integral_1550 library="Design kits/EBeam" wg_length=0.000640597 wg_width=5e-07 points="[[2714.05,2648.35],[2740.05,2648.35],[2740.05,2706.0],[3300.1,2706.0]]" radius=5e-06 lay_x=3.007075E-3 lay_y=2.677175E-3 sch_x=87.12617296E0 sch_y=77.567740111E0
 ebeam_bdc_te1550_6  N$12 N$13 N$10 N$11 ebeam_bdc_te1550 library="Design kits/ebeam"  lay_x=3.074725E-3 lay_y=2.60335E-3 sch_x=89.086245655E0 sch_y=75.428754645E0  sch_r=180 sch_f=true
 wg_heater_7  wg_heater_7_elec1 wg_heater_7_elec2 N$10 N$14 wg_heater library="Design kits/EBeam" wg_length=120.000u lay_x=3.1701E-3 lay_y=2.601E-3 sch_x=91.849614958E0 sch_y=75.360666385E0
 ebeam_bdc_te1550_8  N$3 N$15 N$16 N$17 ebeam_bdc_te1550 library="Design kits/ebeam"  lay_x=3.335475E-3 lay_y=2.70835E-3 sch_x=96.641145217E0 sch_y=78.47099608E0  sch_r=180 sch_f=true
 ebeam_bdc_te1550_9  N$19 N$20 N$21 N$18 ebeam_bdc_te1550 library="Design kits/ebeam"  lay_x=3.576075E-3 lay_y=2.70835E-3 sch_x=103.612224161E0 sch_y=78.47099608E0  sch_r=180 sch_f=true
 wg_heater_10  wg_heater_10_elec1 wg_heater_10_elec2 N$22 N$23 wg_heater library="Design kits/EBeam" wg_length=120.000u lay_x=3.45555E-3 lay_y=2.72835E-3 sch_x=100.1201656E0 sch_y=79.050470639E0  sch_r=180 sch_f=true
 ebeam_terminator_te1550_11  N$15 ebeam_terminator_te1550 library="Design kits/ebeam"  lay_x=3.29465E-3 lay_y=2.7107E-3 sch_x=95.458292774E0 sch_y=78.53908434E0  sch_r=180 sch_f=true
 ebeam_terminator_te1550_12  N$18 ebeam_terminator_te1550 library="Design kits/ebeam"  lay_x=3.6169E-3 lay_y=2.7107E-3 sch_x=104.795076604E0 sch_y=78.53908434E0  sch_f=true
 ebeam_wg_integral_1550_13  N$16 N$19 ebeam_wg_integral_1550 library="Design kits/EBeam" wg_length=0.000198943 wg_width=5e-07 points="[[3370.85,2706.0],[3380.85,2706.0],[3380.85,2688.35],[3530.7,2688.35],[3530.7,2706.0],[3540.7,2706.0]]" radius=5e-06 lay_x=3.455775E-3 lay_y=2.697175E-3 sch_x=100.126684689E0 sch_y=78.14721467E0
 ebeam_wg_integral_1550_14  N$17 N$22 ebeam_wg_integral_1550 library="Design kits/EBeam" wg_length=0.000039247 wg_width=5e-07 points="[[3370.85,2710.7],[3380.85,2710.7],[3380.85,2728.35],[3395.55,2728.35]]" radius=5e-06 lay_x=3.3832E-3 lay_y=2.719525E-3 sch_x=98.023916383E0 sch_y=78.794777489E0
 ebeam_wg_integral_1550_15  N$23 N$20 ebeam_wg_integral_1550 library="Design kits/EBeam" wg_length=0.000039697 wg_width=5e-07 points="[[3515.55,2728.35],[3530.7,2728.35],[3530.7,2710.7],[3540.7,2710.7]]" radius=5e-06 lay_x=3.528125E-3 lay_y=2.719525E-3 sch_x=102.222933906E0 sch_y=78.794777489E0
 wg_heater_16  wg_heater_16_elec1 wg_heater_16_elec2 N$24 N$25 wg_heater library="Design kits/EBeam" wg_length=120.000u lay_x=2.9542E-3 lay_y=2.62335E-3 sch_x=85.594187095E0 sch_y=76.008229204E0  sch_r=180 sch_f=true
 ebeam_y_1550_17  N$21 N$26 N$27 ebeam_y_1550 library="Design kits/ebeam"  lay_x=3.61885E-3 lay_y=2.706E-3 sch_x=104.851575373E0 sch_y=78.402907819E0
 ebeam_wg_integral_1550_18  N$26 N$27 ebeam_wg_integral_1550 library="Design kits/EBeam" wg_length=0.000120390 wg_width=5e-07 points="[[3626.25,2708.75],[3638.85,2708.75],[3638.85,2721.0],[3663.85,2721.0],[3663.85,2691.0],[3638.85,2691.0],[3638.85,2703.25],[3626.25,2703.25]]" radius=5e-06 lay_x=3.645425E-3 lay_y=2.706E-3 sch_x=105.621552194E0 sch_y=78.402907819E0
 ebeam_wg_integral_1550_19  N$14 N$28 ebeam_wg_integral_1550 library="Design kits/EBeam" wg_length=0.000396350 wg_width=5e-07 points="[[3230.1,2601.0],[3626.45,2601.0]]" radius=5e-06 lay_x=3.428275E-3 lay_y=2.601E-3 sch_x=99.32990717E0 sch_y=75.360666385E0
 ebeam_y_1550_20  N$28 N$29 N$30 ebeam_y_1550 library="Design kits/ebeam"  lay_x=3.63385E-3 lay_y=2.601E-3 sch_x=105.286181293E0 sch_y=75.360666385E0
 ebeam_wg_integral_1550_21  N$29 N$30 ebeam_wg_integral_1550 library="Design kits/EBeam" wg_length=0.000120390 wg_width=5e-07 points="[[3641.25,2603.75],[3653.85,2603.75],[3653.85,2616.0],[3678.85,2616.0],[3678.85,2586.0],[3653.85,2586.0],[3653.85,2598.25],[3641.25,2598.25]]" radius=5e-06 lay_x=3.660425E-3 lay_y=2.601E-3 sch_x=106.056158113E0 sch_y=75.360666385E0
 ebeam_bdc_te1550_22  N$1 N$0 N$31 N$32 ebeam_bdc_te1550 library="Design kits/ebeam"  lay_x=2.834125E-3 lay_y=2.60335E-3 sch_x=82.115166712E0 sch_y=75.428754645E0  sch_r=180 sch_f=true
 ebeam_terminator_te1550_23  N$11 ebeam_terminator_te1550 library="Design kits/ebeam"  lay_x=3.11555E-3 lay_y=2.6057E-3 sch_x=90.269098099E0 sch_y=75.496842906E0  sch_f=true
 ebeam_wg_integral_1550_24  N$31 N$12 ebeam_wg_integral_1550 library="Design kits/EBeam" wg_length=0.000198943 wg_width=5e-07 points="[[2869.5,2601.0],[2879.5,2601.0],[2879.5,2583.35],[3029.35,2583.35],[3029.35,2601.0],[3039.35,2601.0]]" radius=5e-06 lay_x=2.954425E-3 lay_y=2.592175E-3 sch_x=85.600706184E0 sch_y=75.104973236E0
 ebeam_wg_integral_1550_25  N$32 N$24 ebeam_wg_integral_1550 library="Design kits/EBeam" wg_length=0.000039247 wg_width=5e-07 points="[[2869.5,2605.7],[2879.5,2605.7],[2879.5,2623.35],[2894.2,2623.35]]" radius=5e-06 lay_x=2.88185E-3 lay_y=2.614525E-3 sch_x=83.497937878E0 sch_y=75.752536055E0
 ebeam_wg_integral_1550_26  N$25 N$13 ebeam_wg_integral_1550 library="Design kits/EBeam" wg_length=0.000039697 wg_width=5e-07 points="[[3014.2,2623.35],[3029.35,2623.35],[3029.35,2605.7],[3039.35,2605.7]]" radius=5e-06 lay_x=3.026775E-3 lay_y=2.614525E-3 sch_x=87.696955401E0 sch_y=75.752536055E0
 ebeam_wg_integral_1550_27  N$34 N$33 ebeam_wg_integral_1550 library="Design kits/EBeam" wg_length=0.000786847 wg_width=5e-07 points="[[2643.3,2648.35],[2631.3,2648.35],[2631.3,2765.0],[1970.0,2765.0]]" radius=5e-06 lay_x=2.30665E-3 lay_y=2.706675E-3 sch_x=66.832249564E0 sch_y=78.422465085E0
 GC_TE_1550_8degOxide_BB_28  GC_TE_1550_8degOxide_BB_detector2 N$35 GC_TE_1550_8degOxide_BB library="Design kits/ebeam"  lay_x=1.950015E-3 lay_y=2.511084E-3 sch_x=56.499204099E0 sch_y=72.755464663E0
 GC_TE_1550_8degOxide_BB_29  GC_TE_1550_8degOxide_BB_laser N$36 GC_TE_1550_8degOxide_BB library="Design kits/ebeam"  lay_x=1.950015E-3 lay_y=2.638084E-3 sch_x=56.499204099E0 sch_y=76.435128112E0
 GC_TE_1550_8degOxide_BB_30  GC_TE_1550_8degOxide_BB_detector1 N$33 GC_TE_1550_8degOxide_BB library="Design kits/ebeam"  lay_x=1.950015E-3 lay_y=2.765084E-3 sch_x=56.499204099E0 sch_y=80.114791561E0
 ebeam_bdc_te1550_31  N$40 N$37 N$38 N$39 ebeam_bdc_te1550 library="Design kits/ebeam"  lay_x=2.325975E-3 lay_y=2.51335E-3 sch_x=67.392166857E0 sch_y=72.82111913E0  sch_r=180
 ebeam_bdc_te1550_32  N$42 N$43 N$44 N$41 ebeam_bdc_te1550 library="Design kits/ebeam"  lay_x=2.085375E-3 lay_y=2.51335E-3 sch_x=60.421087913E0 sch_y=72.82111913E0  sch_r=180
 wg_heater_33  wg_heater_33_elec1 wg_heater_33_elec2 N$45 N$46 wg_heater library="Design kits/EBeam" wg_length=120.000u lay_x=2.2059E-3 lay_y=2.53335E-3 sch_x=63.913146474E0 sch_y=73.400593689E0  sch_r=180
 ebeam_terminator_te1550_34  N$37 ebeam_terminator_te1550 library="Design kits/ebeam"  lay_x=2.3668E-3 lay_y=2.5157E-3 sch_x=68.5750193E0 sch_y=72.889207391E0  sch_r=180
 ebeam_terminator_te1550_35  N$41 ebeam_terminator_te1550 library="Design kits/ebeam"  lay_x=2.04455E-3 lay_y=2.5157E-3 sch_x=59.23823547E0 sch_y=72.889207391E0
 ebeam_wg_integral_1550_36  N$38 N$42 ebeam_wg_integral_1550 library="Design kits/EBeam" wg_length=0.000198943 wg_width=5e-07 points="[[2290.6,2511.0],[2280.6,2511.0],[2280.6,2493.35],[2130.75,2493.35],[2130.75,2511.0],[2120.75,2511.0]]" radius=5e-06 lay_x=2.205675E-3 lay_y=2.502175E-3 sch_x=63.906627385E0 sch_y=72.497337721E0
 ebeam_wg_integral_1550_37  N$39 N$45 ebeam_wg_integral_1550 library="Design kits/EBeam" wg_length=0.000039247 wg_width=5e-07 points="[[2290.6,2515.7],[2280.6,2515.7],[2280.6,2533.35],[2265.9,2533.35]]" radius=5e-06 lay_x=2.27825E-3 lay_y=2.524525E-3 sch_x=66.009395691E0 sch_y=73.14490054E0
 ebeam_wg_integral_1550_38  N$46 N$43 ebeam_wg_integral_1550 library="Design kits/EBeam" wg_length=0.000039697 wg_width=5e-07 points="[[2145.9,2533.35],[2130.75,2533.35],[2130.75,2515.7],[2120.75,2515.7]]" radius=5e-06 lay_x=2.133325E-3 lay_y=2.524525E-3 sch_x=61.810378168E0 sch_y=73.14490054E0
 ebeam_wg_integral_1550_39  N$35 N$44 ebeam_wg_integral_1550 library="Design kits/EBeam" wg_length=0.000080000 wg_width=5e-07 points="[[1970.0,2511.0],[2050.0,2511.0]]" radius=5e-06 lay_x=2.01E-3 lay_y=2.511E-3 sch_x=58.237193169E0 sch_y=72.75303087E0
 ebeam_bdc_te1550_40  N$50 N$47 N$48 N$49 ebeam_bdc_te1550 library="Design kits/ebeam"  lay_x=2.325975E-3 lay_y=2.38635E-3 sch_x=67.392166857E0 sch_y=69.141455681E0  sch_r=180
 ebeam_bdc_te1550_41  N$52 N$53 N$54 N$51 ebeam_bdc_te1550 library="Design kits/ebeam"  lay_x=2.085375E-3 lay_y=2.38635E-3 sch_x=60.421087913E0 sch_y=69.141455681E0  sch_r=180
 wg_heater_42  wg_heater_42_elec1 wg_heater_42_elec2 N$55 N$56 wg_heater library="Design kits/EBeam" wg_length=120.000u lay_x=2.2059E-3 lay_y=2.40635E-3 sch_x=63.913146474E0 sch_y=69.72093024E0  sch_r=180
 ebeam_terminator_te1550_43  N$47 ebeam_terminator_te1550 library="Design kits/ebeam"  lay_x=2.3668E-3 lay_y=2.3887E-3 sch_x=68.5750193E0 sch_y=69.209543942E0  sch_r=180
 ebeam_terminator_te1550_44  N$51 ebeam_terminator_te1550 library="Design kits/ebeam"  lay_x=2.04455E-3 lay_y=2.3887E-3 sch_x=59.23823547E0 sch_y=69.209543942E0
 ebeam_wg_integral_1550_45  N$48 N$52 ebeam_wg_integral_1550 library="Design kits/EBeam" wg_length=0.000198943 wg_width=5e-07 points="[[2290.6,2384.0],[2280.6,2384.0],[2280.6,2366.35],[2130.75,2366.35],[2130.75,2384.0],[2120.75,2384.0]]" radius=5e-06 lay_x=2.205675E-3 lay_y=2.375175E-3 sch_x=63.906627385E0 sch_y=68.817674272E0
 ebeam_wg_integral_1550_46  N$49 N$55 ebeam_wg_integral_1550 library="Design kits/EBeam" wg_length=0.000039247 wg_width=5e-07 points="[[2290.6,2388.7],[2280.6,2388.7],[2280.6,2406.35],[2265.9,2406.35]]" radius=5e-06 lay_x=2.27825E-3 lay_y=2.397525E-3 sch_x=66.009395691E0 sch_y=69.465237091E0
 ebeam_wg_integral_1550_47  N$56 N$53 ebeam_wg_integral_1550 library="Design kits/EBeam" wg_length=0.000039697 wg_width=5e-07 points="[[2145.9,2406.35],[2130.75,2406.35],[2130.75,2388.7],[2120.75,2388.7]]" radius=5e-06 lay_x=2.133325E-3 lay_y=2.397525E-3 sch_x=61.810378168E0 sch_y=69.465237091E0
 ebeam_wg_integral_1550_48  N$57 N$54 ebeam_wg_integral_1550 library="Design kits/EBeam" wg_length=0.000080000 wg_width=5e-07 points="[[1970.0,2384.0],[2050.0,2384.0]]" radius=5e-06 lay_x=2.01E-3 lay_y=2.384E-3 sch_x=58.237193169E0 sch_y=69.073367421E0
 ebeam_y_1550_49  N$58 N$60 N$59 ebeam_y_1550 library="Design kits/ebeam"  lay_x=2.43135E-3 lay_y=2.578E-3 sch_x=70.445273439E0 sch_y=74.694270642E0
 ebeam_y_1550_50  N$61 N$63 N$62 ebeam_y_1550 library="Design kits/ebeam"  lay_x=2.52135E-3 lay_y=2.58075E-3 sch_x=73.052908954E0 sch_y=74.773948394E0
 ebeam_wg_integral_1550_51  N$36 N$58 ebeam_wg_integral_1550 library="Design kits/EBeam" wg_length=0.000510847 wg_width=5e-07 points="[[1970.0,2638.0],[2393.95,2638.0],[2393.95,2578.0],[2423.95,2578.0]]" radius=5e-06 lay_x=2.196975E-3 lay_y=2.608E-3 sch_x=63.654555952E0 sch_y=75.56348248E0
 ebeam_wg_integral_1550_52  N$59 N$40 ebeam_wg_integral_1550 library="Design kits/EBeam" wg_length=0.000158547 wg_width=5e-07 points="[[2438.75,2575.25],[2448.75,2575.25],[2448.75,2511.0],[2361.35,2511.0]]" radius=5e-06 lay_x=2.405425E-3 lay_y=2.543125E-3 sch_x=69.694129542E0 sch_y=73.68381188E0
 ebeam_wg_integral_1550_53  N$60 N$61 ebeam_wg_integral_1550 library="Design kits/EBeam" wg_length=0.000075200 wg_width=5e-07 points="[[2438.75,2580.75],[2513.95,2580.75]]" radius=5e-06 lay_x=2.47635E-3 lay_y=2.58075E-3 sch_x=71.749091196E0 sch_y=74.773948394E0
 ebeam_wg_integral_1550_54  N$62 N$50 ebeam_wg_integral_1550 library="Design kits/EBeam" wg_length=0.000378297 wg_width=5e-07 points="[[2528.75,2578.0],[2538.75,2578.0],[2538.75,2384.0],[2361.35,2384.0]]" radius=5e-06 lay_x=2.450425E-3 lay_y=2.481E-3 sch_x=70.997947299E0 sch_y=71.883819031E0
 ebeam_bdc_te1550_55  N$64 N$34 N$2 N$4 ebeam_bdc_te1550 library="Design kits/ebeam"  lay_x=2.678675E-3 lay_y=2.646E-3 sch_x=77.611200703E0 sch_y=76.664484142E0  sch_r=180 sch_f=true
 ebeam_wg_integral_1550_56  N$63 N$64 ebeam_wg_integral_1550 library="Design kits/EBeam" wg_length=0.000171597 wg_width=5e-07 points="[[2528.75,2583.5],[2603.3,2583.5],[2603.3,2643.65],[2643.3,2643.65]]" radius=5e-06 lay_x=2.586025E-3 lay_y=2.613575E-3 sch_x=74.926784809E0 sch_y=75.725011014E0
 GC_TE_1550_8degOxide_BB_57  GC_TE_1550_8degOxide_BB_detector3 N$57 GC_TE_1550_8degOxide_BB library="Design kits/ebeam"  lay_x=1.950015E-3 lay_y=2.384084E-3 sch_x=56.499204099E0 sch_y=69.075801214E0
.ends EBeam_heaters_atharvdubey_ALU4

EBeam_heaters_atharvdubey_ALU4  wg_heater_7_elec1 wg_heater_7_elec2 wg_heater_10_elec1 wg_heater_10_elec2 wg_heater_16_elec1 wg_heater_16_elec2 wg_heater_33_elec1 wg_heater_33_elec2 wg_heater_42_elec1 wg_heater_42_elec2  GC_TE_1550_8degOxide_BB_detector2 GC_TE_1550_8degOxide_BB_laser GC_TE_1550_8degOxide_BB_detector1 GC_TE_1550_8degOxide_BB_detector3 EBeam_heaters_atharvdubey_ALU4 sch_x=-1 sch_y=-1 sch_r=270
