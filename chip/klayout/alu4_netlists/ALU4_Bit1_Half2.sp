* Spice output from KLayout SiEPIC-Tools v0.5.31, 2026-10-15 13:02:25.

.subckt EBeam_heaters_atharvdubey_ALU4 wg_heater_392_elec1 wg_heater_392_elec2 wg_heater_401_elec1 wg_heater_401_elec2 wg_heater_424_elec1 wg_heater_424_elec2 wg_heater_430_elec1 wg_heater_430_elec2 wg_heater_442_elec1 wg_heater_442_elec2 GC_TE_1550_8degOxide_BB_detector3 GC_TE_1550_8degOxide_BB_detector2 GC_TE_1550_8degOxide_BB_laser GC_TE_1550_8degOxide_BB_detector1
.param MC_uniformity_width=0
.param MC_uniformity_thickness=0
.param MC_resolution_x=100
.param MC_resolution_y=100
.param MC_grid=10e-6
.param MC_non_uniform=0
 ebeam_terminator_te1550_336  N$367 ebeam_terminator_te1550 library="Design kits/ebeam"  lay_x=2.7933E-3 lay_y=319.7E-6 sch_x=80.932314269E0 sch_y=9.262900824E0  sch_r=180 sch_f=true
 ebeam_wg_integral_1550_337  N$368 N$369 ebeam_wg_integral_1550 library="Design kits/EBeam" wg_length=0.000124247 wg_width=5e-07 points="[[2714.05,357.65],[2756.4,357.65],[2756.4,315.0],[2798.75,315.0]]" radius=5e-06 lay_x=2.7564E-3 lay_y=336.325E-6 sch_x=79.863183707E0 sch_y=9.744589051E0
 ebeam_wg_integral_1550_338  N$370 N$371 ebeam_wg_integral_1550 library="Design kits/EBeam" wg_length=0.000640597 wg_width=5e-07 points="[[2714.05,362.35],[2740.05,362.35],[2740.05,420.0],[3300.1,420.0]]" radius=5e-06 lay_x=3.007075E-3 lay_y=391.175E-6 sch_x=87.12617296E0 sch_y=11.333798029E0
 ebeam_bdc_te1550_391  N$428 N$429 N$430 N$427 ebeam_bdc_te1550 library="Design kits/ebeam"  lay_x=2.085375E-3 lay_y=227.35E-6 sch_x=60.421087913E0 sch_y=6.587177048E0  sch_r=180
 wg_heater_392  wg_heater_392_elec1 wg_heater_392_elec2 N$431 N$432 wg_heater library="Design kits/EBeam" wg_length=120.000u lay_x=2.2059E-3 lay_y=247.35E-6 sch_x=63.913146474E0 sch_y=7.166651607E0  sch_r=180
 ebeam_terminator_te1550_393  N$433 ebeam_terminator_te1550 library="Design kits/ebeam"  lay_x=2.3668E-3 lay_y=229.7E-6 sch_x=68.5750193E0 sch_y=6.655265309E0  sch_r=180
 ebeam_terminator_te1550_394  N$427 ebeam_terminator_te1550 library="Design kits/ebeam"  lay_x=2.04455E-3 lay_y=229.7E-6 sch_x=59.23823547E0 sch_y=6.655265309E0
 ebeam_wg_integral_1550_395  N$434 N$428 ebeam_wg_integral_1550 library="Design kits/EBeam" wg_length=0.000198943 wg_width=5e-07 points="[[2290.6,225.0],[2280.6,225.0],[2280.6,207.35],[2130.75,207.35],[2130.75,225.0],[2120.75,225.0]]" radius=5e-06 lay_x=2.205675E-3 lay_y=216.175E-6 sch_x=63.906627385E0 sch_y=6.263395638E0
 ebeam_wg_integral_1550_396  N$435 N$431 ebeam_wg_integral_1550 library="Design kits/EBeam" wg_length=0.000039247 wg_width=5e-07 points="[[2290.6,229.7],[2280.6,229.7],[2280.6,247.35],[2265.9,247.35]]" radius=5e-06 lay_x=2.27825E-3 lay_y=238.525E-6 sch_x=66.009395691E0 sch_y=6.910958458E0
 ebeam_wg_integral_1550_397  N$432 N$429 ebeam_wg_integral_1550 library="Design kits/EBeam" wg_length=0.000039697 wg_width=5e-07 points="[[2145.9,247.35],[2130.75,247.35],[2130.75,229.7],[2120.75,229.7]]" radius=5e-06 lay_x=2.133325E-3 lay_y=238.525E-6 sch_x=61.810378168E0 sch_y=6.910958458E0
 ebeam_wg_integral_1550_398  N$436 N$430 ebeam_wg_integral_1550 library="Design kits/EBeam" wg_length=0.000080000 wg_width=5e-07 points="[[1970.0,225.0],[2050.0,225.0]]" radius=5e-06 lay_x=2.01E-3 lay_y=225.0E-6 sch_x=58.237193169E0 sch_y=6.519088788E0
 ebeam_bdc_te1550_399  N$440 N$437 N$438 N$439 ebeam_bdc_te1550 library="Design kits/ebeam"  lay_x=2.325975E-3 lay_y=100.35E-6 sch_x=67.392166857E0 sch_y=2.907513599E0  sch_r=180
 ebeam_bdc_te1550_400  N$442 N$443 N$444 N$441 ebeam_bdc_te1550 library="Design kits/ebeam"  lay_x=2.085375E-3 lay_y=100.35E-6 sch_x=60.421087913E0 sch_y=2.907513599E0  sch_r=180
 wg_heater_401  wg_heater_401_elec1 wg_heater_401_elec2 N$445 N$446 wg_heater library="Design kits/EBeam" wg_length=120.000u lay_x=2.2059E-3 lay_y=120.35E-6 sch_x=63.913146474E0 sch_y=3.486988158E0  sch_r=180
 ebeam_terminator_te1550_402  N$437 ebeam_terminator_te1550 library="Design kits/ebeam"  lay_x=2.3668E-3 lay_y=102.7E-6 sch_x=68.5750193E0 sch_y=2.97560186E0  sch_r=180
 ebeam_terminator_te1550_403  N$441 ebeam_terminator_te1550 library="Design kits/ebeam"  lay_x=2.04455E-3 lay_y=102.7E-6 sch_x=59.23823547E0 sch_y=2.97560186E0
 ebeam_wg_integral_1550_404  N$438 N$442 ebeam_wg_integral_1550 library="Design kits/EBeam" wg_length=0.000198943 wg_width=5e-07 points="[[2290.6,98.0],[2280.6,98.0],[2280.6,80.35],[2130.75,80.35],[2130.75,98.0],[2120.75,98.0]]" radius=5e-06 lay_x=2.205675E-3 lay_y=89.175E-6 sch_x=63.906627385E0 sch_y=2.583732189E0
 ebeam_wg_integral_1550_405  N$439 N$445 ebeam_wg_integral_1550 library="Design kits/EBeam" wg_length=0.000039247 wg_width=5e-07 points="[[2290.6,102.7],[2280.6,102.7],[2280.6,120.35],[2265.9,120.35]]" radius=5e-06 lay_x=2.27825E-3 lay_y=111.525E-6 sch_x=66.009395691E0 sch_y=3.231295009E0
 ebeam_wg_integral_1550_406  N$446 N$443 ebeam_wg_integral_1550 library="Design kits/EBeam" wg_length=0.000039697 wg_width=5e-07 points="[[2145.9,120.35],[2130.75,120.35],[2130.75,102.7],[2120.75,102.7]]" radius=5e-06 lay_x=2.133325E-3 lay_y=111.525E-6 sch_x=61.810378168E0 sch_y=3.231295009E0
 ebeam_wg_integral_1550_407  N$447 N$444 ebeam_wg_integral_1550 library="Design kits/EBeam" wg_length=0.000080000 wg_width=5e-07 points="[[1970.0,98.0],[2050.0,98.0]]" radius=5e-06 lay_x=2.01E-3 lay_y=98.0E-6 sch_x=58.237193169E0 sch_y=2.839425339E0
 ebeam_y_1550_408  N$448 N$450 N$449 ebeam_y_1550 library="Design kits/ebeam"  lay_x=2.43135E-3 lay_y=292.0E-6 sch_x=70.445273439E0 sch_y=8.46032856E0
 ebeam_y_1550_409  N$451 N$453 N$452 ebeam_y_1550 library="Design kits/ebeam"  lay_x=2.52135E-3 lay_y=294.75E-6 sch_x=73.052908954E0 sch_y=8.540006312E0
 ebeam_wg_integral_1550_410  N$454 N$448 ebeam_wg_integral_1550 library="Design kits/EBeam" wg_length=0.000510847 wg_width=5e-07 points="[[1970.0,352.0],[2393.95,352.0],[2393.95,292.0],[2423.95,292.0]]" radius=5e-06 lay_x=2.196975E-3 lay_y=322.0E-6 sch_x=63.654555952E0 sch_y=9.329540398E0
 ebeam_wg_integral_1550_411  N$449 N$455 ebeam_wg_integral_1550 library="Design kits/EBeam" wg_length=0.000158547 wg_width=5e-07 points="[[2438.75,289.25],[2448.75,289.25],[2448.75,225.0],[2361.35,225.0]]" radius=5e-06 lay_x=2.405425E-3 lay_y=257.125E-6 sch_x=69.694129542E0 sch_y=7.449869798E0
 ebeam_wg_integral_1550_412  N$450 N$451 ebeam_wg_integral_1550 library="Design kits/EBeam" wg_length=0.000075200 wg_width=5e-07 points="[[2438.75,294.75],[2513.95,294.75]]" radius=5e-06 lay_x=2.47635E-3 lay_y=294.75E-6 sch_x=71.749091196E0 sch_y=8.540006312E0
 ebeam_wg_integral_1550_413  N$452 N$440 ebeam_wg_integral_1550 library="Design kits/EBeam" wg_length=0.000378297 wg_width=5e-07 points="[[2528.75,292.0],[2538.75,292.0],[2538.75,98.0],[2361.35,98.0]]" radius=5e-06 lay_x=2.450425E-3 lay_y=195.0E-6 sch_x=70.997947299E0 sch_y=5.649876949E0
 ebeam_bdc_te1550_414  N$456 N$457 N$368 N$370 ebeam_bdc_te1550 library="Design kits/ebeam"  lay_x=2.678675E-3 lay_y=360.0E-6 sch_x=77.611200703E0 sch_y=10.43054206E0  sch_r=180 sch_f=true
 ebeam_wg_integral_1550_415  N$453 N$456 ebeam_wg_integral_1550 library="Design kits/EBeam" wg_length=0.000171597 wg_width=5e-07 points="[[2528.75,297.5],[2603.3,297.5],[2603.3,357.65],[2643.3,357.65]]" radius=5e-06 lay_x=2.586025E-3 lay_y=327.575E-6 sch_x=74.926784809E0 sch_y=9.491068932E0
 ebeam_wg_integral_1550_416  N$457 N$458 ebeam_wg_integral_1550 library="Design kits/EBeam" wg_length=0.000786847 wg_width=5e-07 points="[[2643.3,362.35],[2631.3,362.35],[2631.3,479.0],[1970.0,479.0]]" radius=5e-06 lay_x=2.30665E-3 lay_y=420.675E-6 sch_x=66.832249564E0 sch_y=12.188523003E0
 GC_TE_1550_8degOxide_BB_417  GC_TE_1550_8degOxide_BB_detector3 N$447 GC_TE_1550_8degOxide_BB library="Design kits/ebeam"  lay_x=1.950015E-3 lay_y=98.084E-6 sch_x=56.499204099E0 sch_y=2.841859132E0
 GC_TE_1550_8degOxide_BB_418  GC_TE_1550_8degOxide_BB_detector2 N$436 GC_TE_1550_8degOxide_BB library="Design kits/ebeam"  lay_x=1.950015E-3 lay_y=225.084E-6 sch_x=56.499204099E0 sch_y=6.521522581E0
 GC_TE_1550_8degOxide_BB_419  GC_TE_1550_8degOxide_BB_laser N$454 GC_TE_1550_8degOxide_BB library="Design kits/ebeam"  lay_x=1.950015E-3 lay_y=352.084E-6 sch_x=56.499204099E0 sch_y=10.20118603E0
 GC_TE_1550_8degOxide_BB_420  GC_TE_1550_8degOxide_BB_detector1 N$458 GC_TE_1550_8degOxide_BB library="Design kits/ebeam"  lay_x=1.950015E-3 lay_y=479.084E-6 sch_x=56.499204099E0 sch_y=13.880849479E0
 ebeam_bdc_te1550_421  N$455 N$433 N$434 N$435 ebeam_bdc_te1550 library="Design kits/ebeam"  lay_x=2.325975E-3 lay_y=227.35E-6 sch_x=67.392166857E0 sch_y=6.587177048E0  sch_r=180
 ebeam_bdc_te1550_422  N$371 N$459 N$460 N$461 ebeam_bdc_te1550 library="Design kits/ebeam"  lay_x=3.335475E-3 lay_y=422.35E-6 sch_x=96.641145217E0 sch_y=12.237053998E0  sch_r=180 sch_f=true
 ebeam_bdc_te1550_423  N$463 N$464 N$465 N$462 ebeam_bdc_te1550 library="Design kits/ebeam"  lay_x=3.576075E-3 lay_y=422.35E-6 sch_x=103.612224161E0 sch_y=12.237053998E0  sch_r=180 sch_f=true
 wg_heater_424  wg_heater_424_elec1 wg_heater_424_elec2 N$466 N$467 wg_heater library="Design kits/EBeam" wg_length=120.000u lay_x=3.45555E-3 lay_y=442.35E-6 sch_x=100.1201656E0 sch_y=12.816528556E0  sch_r=180 sch_f=true
 ebeam_terminator_te1550_425  N$459 ebeam_terminator_te1550 library="Design kits/ebeam"  lay_x=3.29465E-3 lay_y=424.7E-6 sch_x=95.458292774E0 sch_y=12.305142258E0  sch_r=180 sch_f=true
 ebeam_terminator_te1550_426  N$462 ebeam_terminator_te1550 library="Design kits/ebeam"  lay_x=3.6169E-3 lay_y=424.7E-6 sch_x=104.795076604E0 sch_y=12.305142258E0  sch_f=true
 ebeam_wg_integral_1550_427  N$460 N$463 ebeam_wg_integral_1550 library="Design kits/EBeam" wg_length=0.000198943 wg_width=5e-07 points="[[3370.85,420.0],[3380.85,420.0],[3380.85,402.35],[3530.7,402.35],[3530.7,420.0],[3540.7,420.0]]" radius=5e-06 lay_x=3.455775E-3 lay_y=411.175E-6 sch_x=100.126684689E0 sch_y=11.913272588E0
 ebeam_wg_integral_1550_428  N$461 N$466 ebeam_wg_integral_1550 library="Design kits/EBeam" wg_length=0.000039247 wg_width=5e-07 points="[[3370.85,424.7],[3380.85,424.7],[3380.85,442.35],[3395.55,442.35]]" radius=5e-06 lay_x=3.3832E-3 lay_y=433.525E-6 sch_x=98.023916383E0 sch_y=12.560835407E0
 ebeam_wg_integral_1550_429  N$467 N$464 ebeam_wg_integral_1550 library="Design kits/EBeam" wg_length=0.000039697 wg_width=5e-07 points="[[3515.55,442.35],[3530.7,442.35],[3530.7,424.7],[3540.7,424.7]]" radius=5e-06 lay_x=3.528125E-3 lay_y=433.525E-6 sch_x=102.222933906E0 sch_y=12.560835407E0
 wg_heater_430  wg_heater_430_elec1 wg_heater_430_elec2 N$468 N$469 wg_heater library="Design kits/EBeam" wg_length=120.000u lay_x=2.9542E-3 lay_y=337.35E-6 sch_x=85.594187095E0 sch_y=9.774287122E0  sch_r=180 sch_f=true
 ebeam_y_1550_431  N$465 N$470 N$471 ebeam_y_1550 library="Design kits/ebeam"  lay_x=3.61885E-3 lay_y=420.0E-6 sch_x=104.851575373E0 sch_y=12.168965737E0
 ebeam_wg_integral_1550_432  N$470 N$471 ebeam_wg_integral_1550 library="Design kits/EBeam" wg_length=0.000120390 wg_width=5e-07 points="[[3626.25,422.75],[3638.85,422.75],[3638.85,435.0],[3663.85,435.0],[3663.85,405.0],[3638.85,405.0],[3638.85,417.25],[3626.25,417.25]]" radius=5e-06 lay_x=3.645425E-3 lay_y=420.0E-6 sch_x=105.621552194E0 sch_y=12.168965737E0
 ebeam_wg_integral_1550_433  N$473 N$472 ebeam_wg_integral_1550 library="Design kits/EBeam" wg_length=0.000396350 wg_width=5e-07 points="[[3230.1,315.0],[3626.45,315.0]]" radius=5e-06 lay_x=3.428275E-3 lay_y=315.0E-6 sch_x=99.32990717E0 sch_y=9.126724303E0
 ebeam_y_1550_434  N$472 N$474 N$475 ebeam_y_1550 library="Design kits/ebeam"  lay_x=3.63385E-3 lay_y=315.0E-6 sch_x=105.286181293E0 sch_y=9.126724303E0
 ebeam_wg_integral_1550_435  N$474 N$475 ebeam_wg_integral_1550 library="Design kits/EBeam" wg_length=0.000120390 wg_width=5e-07 points="[[3641.25,317.75],[3653.85,317.75],[3653.85,330.0],[3678.85,330.0],[3678.85,300.0],[3653.85,300.0],[3653.85,312.25],[3641.25,312.25]]" radius=5e-06 lay_x=3.660425E-3 lay_y=315.0E-6 sch_x=106.056158113E0 sch_y=9.126724303E0
 ebeam_bdc_te1550_436  N$369 N$367 N$476 N$477 ebeam_bdc_te1550 library="Design kits/ebeam"  lay_x=2.834125E-3 lay_y=317.35E-6 sch_x=82.115166712E0 sch_y=9.194812563E0  sch_r=180 sch_f=true
 ebeam_terminator_te1550_437  N$478 ebeam_terminator_te1550 library="Design kits/ebeam"  lay_x=3.11555E-3 lay_y=319.7E-6 sch_x=90.269098099E0 sch_y=9.262900824E0  sch_f=true
 ebeam_wg_integral_1550_438  N$476 N$479 ebeam_wg_integral_1550 library="Design kits/EBeam" wg_length=0.000198943 wg_width=5e-07 points="[[2869.5,315.0],[2879.5,315.0],[2879.5,297.35],[3029.35,297.35],[3029.35,315.0],[3039.35,315.0]]" radius=5e-06 lay_x=2.954425E-3 lay_y=306.175E-6 sch_x=85.600706184E0 sch_y=8.871031154E0
 ebeam_wg_integral_1550_439  N$477 N$468 ebeam_wg_integral_1550 library="Design kits/EBeam" wg_length=0.000039247 wg_width=5e-07 points="[[2869.5,319.7],[2879.5,319.7],[2879.5,337.35],[2894.2,337.35]]" radius=5e-06 lay_x=2.88185E-3 lay_y=328.525E-6 sch_x=83.497937878E0 sch_y=9.518593973E0
 ebeam_wg_integral_1550_440  N$469 N$480 ebeam_wg_integral_1550 library="Design kits/EBeam" wg_length=0.000039697 wg_width=5e-07 points="[[3014.2,337.35],[3029.35,337.35],[3029.35,319.7],[3039.35,319.7]]" radius=5e-06 lay_x=3.026775E-3 lay_y=328.525E-6 sch_x=87.696955401E0 sch_y=9.518593973E0
 ebeam_bdc_te1550_441  N$479 N$480 N$481 N$478 ebeam_bdc_te1550 library="Design kits/ebeam"  lay_x=3.074725E-3 lay_y=317.35E-6 sch_x=89.086245655E0 sch_y=9.194812563E0  sch_r=180 sch_f=true
 wg_heater_442  wg_heater_442_elec1 wg_heater_442_elec2 N$481 N$473 wg_heater library="Design kits/EBeam" wg_length=120.000u lay_x=3.1701E-3 lay_y=315.0E-6 sch_x=91.849614958E0 sch_y=9.126724303E0
.ends EBeam_heaters_atharvdubey_ALU4

EBeam_heaters_atharvdubey_ALU4  wg_heater_392_elec1 wg_heater_392_elec2 wg_heater_401_elec1 wg_heater_401_elec2 wg_heater_424_elec1 wg_heater_424_elec2 wg_heater_430_elec1 wg_heater_430_elec2 wg_heater_442_elec1 wg_heater_442_elec2  GC_TE_1550_8degOxide_BB_detector3 GC_TE_1550_8degOxide_BB_detector2 GC_TE_1550_8degOxide_BB_laser GC_TE_1550_8degOxide_BB_detector1 EBeam_heaters_atharvdubey_ALU4 sch_x=-1 sch_y=-1 sch_r=270
