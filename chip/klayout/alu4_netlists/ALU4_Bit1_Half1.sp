* Spice output from KLayout SiEPIC-Tools v0.5.31, 2026-10-15 13:02:24.

.subckt EBeam_heaters_atharvdubey_ALU4 wg_heater_340_elec1 wg_heater_340_elec2 wg_heater_343_elec1 wg_heater_343_elec2 wg_heater_349_elec1 wg_heater_349_elec2 wg_heater_366_elec1 wg_heater_366_elec2 wg_heater_375_elec1 wg_heater_375_elec2 GC_TE_1550_8degOxide_BB_detector2 GC_TE_1550_8degOxide_BB_laser GC_TE_1550_8degOxide_BB_detector1 GC_TE_1550_8degOxide_BB_detector3
.param MC_uniformity_width=0
.param MC_uniformity_thickness=0
.param MC_resolution_x=100
.param MC_resolution_y=100
.param MC_grid=10e-6
.param MC_non_uniform=0
 ebeam_terminator_te1550_333  N$362 ebeam_terminator_te1550 library="Design kits/ebeam"  lay_x=2.7933E-3 lay_y=1.0817E-3 sch_x=80.932314269E0 sch_y=31.340881518E0  sch_r=180 sch_f=true
 ebeam_wg_integral_1550_334  N$364 N$363 ebeam_wg_integral_1550 library="Design kits/EBeam" wg_length=0.000124247 wg_width=5e-07 points="[[2714.05,1119.65],[2756.4,1119.65],[2756.4,1077.0],[2798.75,1077.0]]" radius=5e-06 lay_x=2.7564E-3 lay_y=1.098325E-3 sch_x=79.863183707E0 sch_y=31.822569745E0
 ebeam_wg_integral_1550_335  N$366 N$365 ebeam_wg_integral_1550 library="Design kits/EBeam" wg_length=0.000640597 wg_width=5e-07 points="[[2714.05,1124.35],[2740.05,1124.35],[2740.05,1182.0],[3300.1,1182.0]]" radius=5e-06 lay_x=3.007075E-3 lay_y=1.153175E-3 sch_x=87.12617296E0 sch_y=33.411778723E0
 ebeam_bdc_te1550_339  N$374 N$375 N$372 N$373 ebeam_bdc_te1550 library="Design kits/ebeam"  lay_x=3.074725E-3 lay_y=1.07935E-3 sch_x=89.086245655E0 sch_y=31.272793257E0  sch_r=180 sch_f=true
 wg_heater_340  wg_heater_340_elec1 wg_heater_340_elec2 N$372 N$376 wg_heater library="Design kits/EBeam" wg_length=120.000u lay_x=3.1701E-3 lay_y=1.077E-3 sch_x=91.849614958E0 sch_y=31.204704997E0
 ebeam_bdc_te1550_341  N$365 N$377 N$378 N$379 ebeam_bdc_te1550 library="Design kits/ebeam"  lay_x=3.335475E-3 lay_y=1.18435E-3 sch_x=96.641145217E0 sch_y=34.315034692E0  sch_r=180 sch_f=true
 ebeam_bdc_te1550_342  N$381 N$382 N$383 N$380 ebeam_bdc_te1550 library="Design kits/ebeam"  lay_x=3.576075E-3 lay_y=1.18435E-3 sch_x=103.612224161E0 sch_y=34.315034692E0  sch_r=180 sch_f=true
 wg_heater_343  wg_heater_343_elec1 wg_heater_343_elec2 N$384 N$385 wg_heater library="Design kits/EBeam" wg_length=120.000u lay_x=3.45555E-3 lay_y=1.20435E-3 sch_x=100.1201656E0 sch_y=34.89450925E0  sch_r=180 sch_f=true
 ebeam_terminator_te1550_344  N$377 ebeam_terminator_te1550 library="Design kits/ebeam"  lay_x=3.29465E-3 lay_y=1.1867E-3 sch_x=95.458292774E0 sch_y=34.383122952E0  sch_r=180 sch_f=true
 ebeam_terminator_te1550_345  N$380 ebeam_terminator_te1550 library="Design kits/ebeam"  lay_x=3.6169E-3 lay_y=1.1867E-3 sch_x=104.795076604E0 sch_y=34.383122952E0  sch_f=true
 ebeam_wg_integral_1550_346  N$378 N$381 ebeam_wg_integral_1550 library="Design kits/EBeam" wg_length=0.000198943 wg_width=5e-07 points="[[3370.85,1182.0],[3380.85,1182.0],[3380.85,1164.35],[3530.7,1164.35],[3530.7,1182.0],[3540.7,1182.0]]" radius=5e-06 lay_x=3.455775E-3 lay_y=1.173175E-3 sch_x=100.126684689E0 sch_y=33.991253282E0
 ebeam_wg_integral_1550_347  N$379 N$384 ebeam_wg_integral_1550 library="Design kits/EBeam" wg_length=0.000039247 wg_width=5e-07 points="[[3370.85,1186.7],[3380.85,1186.7],[3380.85,1204.35],[3395.55,1204.35]]" radius=5e-06 lay_x=3.3832E-3 lay_y=1.195525E-3 sch_x=98.023916383E0 sch_y=34.638816101E0
 ebeam_wg_integral_1550_348  N$385 N$382 ebeam_wg_integral_1550 library="Design kits/EBeam" wg_length=0.000039697 wg_width=5e-07 points="[[3515.55,1204.35],[3530.7,1204.35],[3530.7,1186.7],[3540.7,1186.7]]" radius=5e-06 lay_x=3.528125E-3 lay_y=1.195525E-3 sch_x=102.222933906E0 sch_y=34.638816101E0
 wg_heater_349  wg_heater_349_elec1 wg_heater_349_elec2 N$386 N$387 wg_heater library="Design kits/EBeam" wg_length=120.000u lay_x=2.9542E-3 lay_y=1.09935E-3 sch_x=85.594187095E0 sch_y=31.852267816E0  sch_r=180 sch_f=true
 ebeam_y_1550_350  N$383 N$388 N$389 ebeam_y_1550 library="Design kits/ebeam"  lay_x=3.61885E-3 lay_y=1.182E-3 sch_x=104.851575373E0 sch_y=34.246946431E0
 ebeam_wg_integral_1550_351  N$388 N$389 ebeam_wg_integral_1550 library="Design kits/EBeam" wg_length=0.000120390 wg_width=5e-07 points="[[3626.25,1184.75],[3638.85,1184.75],[3638.85,1197.0],[3663.85,1197.0],[3663.85,1167.0],[3638.85,1167.0],[3638.85,1179.25],[3626.25,1179.25]]" radius=5e-06 lay_x=3.645425E-3 lay_y=1.182E-3 sch_x=105.621552194E0 sch_y=34.246946431E0
 ebeam_wg_integral_1550_352  N$376 N$390 ebeam_wg_integral_1550 library="Design kits/EBeam" wg_length=0.000396350 wg_width=5e-07 points="[[3230.1,1077.0],[3626.45,1077.0]]" radius=5e-06 lay_x=3.428275E-3 lay_y=1.077E-3 sch_x=99.32990717E0 sch_y=31.204704997E0
 ebeam_y_1550_353  N$390 N$391 N$392 ebeam_y_1550 library="Design kits/ebeam"  lay_x=3.63385E-3 lay_y=1.077E-3 sch_x=105.286181293E0 sch_y=31.204704997E0
 ebeam_wg_integral_1550_354  N$391 N$392 ebeam_wg_integral_1550 library="Design kits/EBeam" wg_length=0.000120390 wg_width=5e-07 points="[[3641.25,1079.75],[3653.85,1079.75],[3653.85,1092.0],[3678.85,1092.0],[3678.85,1062.0],[3653.85,1062.0],[3653.85,1074.25],[3641.25,1074.25]]" radius=5e-06 lay_x=3.660425E-3 lay_y=1.077E-3 sch_x=106.056158113E0 sch_y=31.204704997E0
 ebeam_bdc_te1550_355  N$363 N$362 N$393 N$394 ebeam_bdc_te1550 library="Design kits/ebeam"  lay_x=2.834125E-3 lay_y=1.07935E-3 sch_x=82.115166712E0 sch_y=31.272793257E0  sch_r=180 sch_f=true
 ebeam_terminator_te1550_356  N$373 ebeam_terminator_te1550 library="Design kits/ebeam"  lay_x=3.11555E-3 lay_y=1.0817E-3 sch_x=90.269098099E0 sch_y=31.340881518E0  sch_f=true
 ebeam_wg_integral_1550_357  N$393 N$374 ebeam_wg_integral_1550 library="Design kits/EBeam" wg_length=0.000198943 wg_width=5e-07 points="[[2869.5,1077.0],[2879.5,1077.0],[2879.5,1059.35],[3029.35,1059.35],[3029.35,1077.0],[3039.35,1077.0]]" radius=5e-06 lay_x=2.954425E-3 lay_y=1.068175E-3 sch_x=85.600706184E0 sch_y=30.949011848E0
 ebeam_wg_integral_1550_358  N$394 N$386 ebeam_wg_integral_1550 library="Design kits/EBeam" wg_length=0.000039247 wg_width=5e-07 points="[[2869.5,1081.7],[2879.5,1081.7],[2879.5,1099.35],[2894.2,1099.35]]" radius=5e-06 lay_x=2.88185E-3 lay_y=1.090525E-3 sch_x=83.497937878E0 sch_y=31.596574667E0
 ebeam_wg_integral_1550_359  N$387 N$375 ebeam_wg_integral_1550 library="Design kits/EBeam" wg_length=0.000039697 wg_width=5e-07 points="[[3014.2,1099.35],[3029.35,1099.35],[3029.35,1081.7],[3039.35,1081.7]]" radius=5e-06 lay_x=3.026775E-3 lay_y=1.090525E-3 sch_x=87.696955401E0 sch_y=31.596574667E0
 ebeam_wg_integral_1550_360  N$396 N$395 ebeam_wg_integral_1550 library="Design kits/EBeam" wg_length=0.000786847 wg_width=5e-07 points="[[2643.3,1124.35],[2631.3,1124.35],[2631.3,1241.0],[1970.0,1241.0]]" radius=5e-06 lay_x=2.30665E-3 lay_y=1.182675E-3 sch_x=66.832249564E0 sch_y=34.266503697E0
 GC_TE_1550_8degOxide_BB_361  GC_TE_1550_8degOxide_BB_detector2 N$397 GC_TE_1550_8degOxide_BB library="Design kits/ebeam"  lay_x=1.950015E-3 lay_y=987.084E-6 sch_x=56.499204099E0 sch_y=28.599503275E0
 GC_TE_1550_8degOxide_BB_362  GC_TE_1550_8degOxide_BB_laser N$398 GC_TE_1550_8degOxide_BB library="Design kits/ebeam"  lay_x=1.950015E-3 lay_y=1.114084E-3 sch_x=56.499204099E0 sch_y=32.279166724E0
 GC_TE_1550_8degOxide_BB_363  GC_TE_1550_8degOxide_BB_detector1 N$395 GC_TE_1550_8degOxide_BB library="Design kits/ebeam"  lay_x=1.950015E-3 lay_y=1.241084E-3 sch_x=56.499204099E0 sch_y=35.958830173E0
 ebeam_bdc_te1550_364  N$402 N$399 N$400 N$401 ebeam_bdc_te1550 library="Design kits/ebeam"  lay_x=2.325975E-3 lay_y=989.35E-6 sch_x=67.392166857E0 sch_y=28.665157742E0  sch_r=180
 ebeam_bdc_te1550_365  N$404 N$405 N$406 N$403 ebeam_bdc_te1550 library="Design kits/ebeam"  lay_x=2.085375E-3 lay_y=989.35E-6 sch_x=60.421087913E0 sch_y=28.665157742E0  sch_r=180
 wg_heater_366  wg_heater_366_elec1 wg_heater_366_elec2 N$407 N$408 wg_heater library="Design kits/EBeam" wg_length=120.000u lay_x=2.2059E-3 lay_y=1.00935E-3 sch_x=63.913146474E0 sch_y=29.244632301E0  sch_r=180
 ebeam_terminator_te1550_367  N$399 ebeam_terminator_te1550 library="Design kits/ebeam"  lay_x=2.3668E-3 lay_y=991.7E-6 sch_x=68.5750193E0 sch_y=28.733246003E0  sch_r=180
 ebeam_terminator_te1550_368  N$403 ebeam_terminator_te1550 library="Design kits/ebeam"  lay_x=2.04455E-3 lay_y=991.7E-6 sch_x=59.23823547E0 sch_y=28.733246003E0
 ebeam_wg_integral_1550_369  N$400 N$404 ebeam_wg_integral_1550 library="Design kits/EBeam" wg_length=0.000198943 wg_width=5e-07 points="[[2290.6,987.0],[2280.6,987.0],[2280.6,969.35],[2130.75,969.35],[2130.75,987.0],[2120.75,987.0]]" radius=5e-06 lay_x=2.205675E-3 lay_y=978.175E-6 sch_x=63.906627385E0 sch_y=28.341376333E0
 ebeam_wg_integral_1550_370  N$401 N$407 ebeam_wg_integral_1550 library="Design kits/EBeam" wg_length=0.000039247 wg_width=5e-07 points="[[2290.6,991.7],[2280.6,991.7],[2280.6,1009.35],[2265.9,1009.35]]" radius=5e-06 lay_x=2.27825E-3 lay_y=1.000525E-3 sch_x=66.009395691E0 sch_y=28.988939152E0
 ebeam_wg_integral_1550_371  N$408 N$405 ebeam_wg_integral_1550 library="Design kits/EBeam" wg_length=0.000039697 wg_width=5e-07 points="[[2145.9,1009.35],[2130.75,1009.35],[2130.75,991.7],[2120.75,991.7]]" radius=5e-06 lay_x=2.133325E-3 lay_y=1.000525E-3 sch_x=61.810378168E0 sch_y=28.988939152E0
 ebeam_wg_integral_1550_372  N$397 N$406 ebeam_wg_integral_1550 library="Design kits/EBeam" wg_length=0.000080000 wg_width=5e-07 points="[[1970.0,987.0],[2050.0,987.0]]" radius=5e-06 lay_x=2.01E-3 lay_y=987.0E-6 sch_x=58.237193169E0 sch_y=28.597069482E0
 ebeam_bdc_te1550_373  N$412 N$409 N$410 N$411 ebeam_bdc_te1550 library="Design kits/ebeam"  lay_x=2.325975E-3 lay_y=862.35E-6 sch_x=67.392166857E0 sch_y=24.985494293E0  sch_r=180
 ebeam_bdc_te1550_374  N$414 N$415 N$416 N$413 ebeam_bdc_te1550 library="Design kits/ebeam"  lay_x=2.085375E-3 lay_y=862.35E-6 sch_x=60.421087913E0 sch_y=24.985494293E0  sch_r=180
 wg_heater_375  wg_heater_375_elec1 wg_heater_375_elec2 N$417 N$418 wg_heater library="Design kits/EBeam" wg_length=120.000u lay_x=2.2059E-3 lay_y=882.35E-6 sch_x=63.913146474E0 sch_y=25.564968852E0  sch_r=180
 ebeam_terminator_te1550_376  N$409 ebeam_terminator_te1550 library="Design kits/ebeam"  lay_x=2.3668E-3 lay_y=864.7E-6 sch_x=68.5750193E0 sch_y=25.053582554E0  sch_r=180
 ebeam_terminator_te1550_377  N$413 ebeam_terminator_te1550 library="Design kits/ebeam"  lay_x=2.04455E-3 lay_y=864.7E-6 sch_x=59.23823547E0 sch_y=25.053582554E0
 ebeam_wg_integral_1550_378  N$410 N$414 ebeam_wg_integral_1550 library="Design kits/EBeam" wg_length=0.000198943 wg_width=5e-07 points="[[2290.6,860.0],[2280.6,860.0],[2280.6,842.35],[2130.75,842.35],[2130.75,860.0],[2120.75,860.0]]" radius=5e-06 lay_x=2.205675E-3 lay_y=851.175E-6 sch_x=63.906627385E0 sch_y=24.661712884E0
 ebeam_wg_integral_1550_379  N$411 N$417 ebeam_wg_integral_1550 library="Design kits/EBeam" wg_length=0.000039247 wg_width=5e-07 points="[[2290.6,864.7],[2280.6,864.7],[2280.6,882.35],[2265.9,882.35]]" radius=5e-06 lay_x=2.27825E-3 lay_y=873.525E-6 sch_x=66.009395691E0 sch_y=25.309275703E0
 ebeam_wg_integral_1550_380  N$418 N$415 ebeam_wg_integral_1550 library="Design kits/EBeam" wg_length=0.000039697 wg_width=5e-07 points="[[2145.9,882.35],[2130.75,882.35],[2130.75,864.7],[2120.75,864.7]]" radius=5e-06 lay_x=2.133325E-3 lay_y=873.525E-6 sch_x=61.810378168E0 sch_y=25.309275703E0
 ebeam_wg_integral_1550_381  N$419 N$416 ebeam_wg_integral_1550 library="Design kits/EBeam" wg_length=0.000080000 wg_width=5e-07 points="[[1970.0,860.0],[2050.0,860.0]]" radius=5e-06 lay_x=2.01E-3 lay_y=860.0E-6 sch_x=58.237193169E0 sch_y=24.917406033E0
 ebeam_y_1550_382  N$420 N$422 N$421 ebeam_y_1550 library="Design kits/ebeam"  lay_x=2.43135E-3 lay_y=1.054E-3 sch_x=70.445273439E0 sch_y=30.538309254E0
 ebeam_y_1550_383  N$423 N$425 N$424 ebeam_y_1550 library="Design kits/ebeam"  lay_x=2.52135E-3 lay_y=1.05675E-3 sch_x=73.052908954E0 sch_y=30.617987006E0
 ebeam_wg_integral_1550_384  N$398 N$420 ebeam_wg_integral_1550 library="Design kits/EBeam" wg_length=0.000510847 wg_width=5e-07 points="[[1970.0,1114.0],[2393.95,1114.0],[2393.95,1054.0],[2423.95,1054.0]]" radius=5e-06 lay_x=2.196975E-3 lay_y=1.084E-3 sch_x=63.654555952E0 sch_y=31.407521092E0
 ebeam_wg_integral_1550_385  N$421 N$402 ebeam_wg_integral_1550 library="Design kits/EBeam" wg_length=0.000158547 wg_width=5e-07 points="[[2438.75,1051.25],[2448.75,1051.25],[2448.75,987.0],[2361.35,987.0]]" radius=5e-06 lay_x=2.405425E-3 lay_y=1.019125E-3 sch_x=69.694129542E0 sch_y=29.527850492E0
 ebeam_wg_integral_1550_386  N$422 N$423 ebeam_wg_integral_1550 library="Design kits/EBeam" wg_length=0.000075200 wg_width=5e-07 points="[[2438.75,1056.75],[2513.95,1056.75]]" radius=5e-06 lay_x=2.47635E-3 lay_y=1.05675E-3 sch_x=71.749091196E0 sch_y=30.617987006E0
 ebeam_wg_integral_1550_387  N$424 N$412 ebeam_wg_integral_1550 library="Design kits/EBeam" wg_length=0.000378297 wg_width=5e-07 points="[[2528.75,1054.0],[2538.75,1054.0],[2538.75,860.0],[2361.35,860.0]]" radius=5e-06 lay_x=2.450425E-3 lay_y=957.0E-6 sch_x=70.997947299E0 sch_y=27.727857643E0
 ebeam_bdc_te1550_388  N$426 N$396 N$364 N$366 ebeam_bdc_te1550 library="Design kits/ebeam"  lay_x=2.678675E-3 lay_y=1.122E-3 sch_x=77.611200703E0 sch_y=32.508522754E0  sch_r=180 sch_f=true
 ebeam_wg_integral_1550_389  N$425 N$426 ebeam_wg_integral_1550 library="Design kits/EBeam" wg_length=0.000171597 wg_width=5e-07 points="[[2528.75,1059.5],[2603.3,1059.5],[2603.3,1119.65],[2643.3,1119.65]]" radius=5e-06 lay_x=2.586025E-3 lay_y=1.089575E-3 sch_x=74.926784809E0 sch_y=31.569049626E0
 GC_TE_1550_8degOxide_BB_390  GC_TE_1550_8degOxide_BB_detector3 N$419 GC_TE_1550_8degOxide_BB library="Design kits/ebeam"  lay_x=1.950015E-3 lay_y=860.084E-6 sch_x=56.499204099E0 sch_y=24.919839826E0
.ends EBeam_heaters_atharvdubey_ALU4

EBeam_heaters_atharvdubey_ALU4  wg_heater_340_elec1 wg_heater_340_elec2 wg_heater_343_elec1 wg_heater_343_elec2 wg_heater_349_elec1 wg_heater_349_elec2 wg_heater_366_elec1 wg_heater_366_elec2 wg_heater_375_elec1 wg_heater_375_elec2  GC_TE_1550_8degOxide_BB_detector2 GC_TE_1550_8degOxide_BB_laser GC_TE_1550_8degOxide_BB_detector1 GC_TE_1550_8degOxide_BB_detector3 EBeam_heaters_atharvdubey_ALU4 sch_x=-1 sch_y=-1 sch_r=270
