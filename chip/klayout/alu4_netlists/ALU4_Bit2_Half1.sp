* Spice output from KLayout SiEPIC-Tools v0.5.31, 2026-10-15 13:02:25.

.subckt EBeam_heaters_atharvdubey_ALU4 wg_heater_117_elec1 wg_heater_117_elec2 wg_heater_120_elec1 wg_heater_120_elec2 wg_heater_132_elec1 wg_heater_132_elec2 wg_heater_143_elec1 wg_heater_143_elec2 wg_heater_152_elec1 wg_heater_152_elec2 GC_TE_1550_8degOxide_BB_detector2 GC_TE_1550_8degOxide_BB_laser GC_TE_1550_8degOxide_BB_detector1 GC_TE_1550_8degOxide_BB_detector3
.param MC_uniformity_width=0
.param MC_uniformity_thickness=0
.param MC_resolution_x=100
.param MC_resolution_y=100
.param MC_grid=10e-6
.param MC_non_uniform=0
 ebeam_wg_integral_1550_110  N$121 N$120 ebeam_wg_integral_1550 library="Design kits/EBeam" wg_length=0.000124247 wg_width=5e-07 points="[[864.05,2643.65],[906.4,2643.65],[906.4,2601.0],[948.75,2601.0]]" radius=5e-06 lay_x=906.4E-6 lay_y=2.622325E-3 sch_x=26.261787009E0 sch_y=75.978531133E0
 ebeam_wg_integral_1550_111  N$123 N$122 ebeam_wg_integral_1550 library="Design kits/EBeam" wg_length=0.000640597 wg_width=5e-07 points="[[864.05,2648.35],[890.05,2648.35],[890.05,2706.0],[1450.1,2706.0]]" radius=5e-06 lay_x=1.157075E-3 lay_y=2.677175E-3 sch_x=33.524776262E0 sch_y=77.567740111E0
 ebeam_wg_integral_1550_114  N$128 N$129 ebeam_wg_integral_1550 library="Design kits/EBeam" wg_length=0.000039247 wg_width=5e-07 points="[[1019.5,2605.7],[1029.5,2605.7],[1029.5,2623.35],[1044.2,2623.35]]" radius=5e-06 lay_x=1.03185E-3 lay_y=2.614525E-3 sch_x=29.89654118E0 sch_y=75.752536055E0
 ebeam_wg_integral_1550_115  N$131 N$130 ebeam_wg_integral_1550 library="Design kits/EBeam" wg_length=0.000039697 wg_width=5e-07 points="[[1164.2,2623.35],[1179.35,2623.35],[1179.35,2605.7],[1189.35,2605.7]]" radius=5e-06 lay_x=1.176775E-3 lay_y=2.614525E-3 sch_x=34.095558702E0 sch_y=75.752536055E0
 ebeam_bdc_te1550_116  N$120 N$132 N$133 N$128 ebeam_bdc_te1550 library="Design kits/ebeam"  lay_x=984.125E-6 lay_y=2.60335E-3 sch_x=28.513770014E0 sch_y=75.428754645E0  sch_r=180 sch_f=true
 wg_heater_117  wg_heater_117_elec1 wg_heater_117_elec2 N$134 N$135 wg_heater library="Design kits/EBeam" wg_length=120.000u lay_x=1.3201E-3 lay_y=2.601E-3 sch_x=38.24821826E0 sch_y=75.360666385E0
 ebeam_bdc_te1550_118  N$122 N$136 N$137 N$138 ebeam_bdc_te1550 library="Design kits/ebeam"  lay_x=1.485475E-3 lay_y=2.70835E-3 sch_x=43.039748519E0 sch_y=78.47099608E0  sch_r=180 sch_f=true
 ebeam_bdc_te1550_119  N$140 N$141 N$142 N$139 ebeam_bdc_te1550 library="Design kits/ebeam"  lay_x=1.726075E-3 lay_y=2.70835E-3 sch_x=50.010827463E0 sch_y=78.47099608E0  sch_r=180 sch_f=true
 wg_heater_120  wg_heater_120_elec1 wg_heater_120_elec2 N$143 N$144 wg_heater library="Design kits/EBeam" wg_length=120.000u lay_x=1.60555E-3 lay_y=2.72835E-3 sch_x=46.518768902E0 sch_y=79.050470639E0  sch_r=180 sch_f=true
 ebeam_terminator_te1550_121  N$136 ebeam_terminator_te1550 library="Design kits/ebeam"  lay_x=1.44465E-3 lay_y=2.7107E-3 sch_x=41.856896076E0 sch_y=78.53908434E0  sch_r=180 sch_f=true
 ebeam_terminator_te1550_122  N$139 ebeam_terminator_te1550 library="Design kits/ebeam"  lay_x=1.7669E-3 lay_y=2.7107E-3 sch_x=51.193679906E0 sch_y=78.53908434E0  sch_f=true
 ebeam_wg_integral_1550_123  N$137 N$140 ebeam_wg_integral_1550 library="Design kits/EBeam" wg_length=0.000198943 wg_width=5e-07 points="[[1520.85,2706.0],[1530.85,2706.0],[1530.85,2688.35],[1680.7,2688.35],[1680.7,2706.0],[1690.7,2706.0]]" radius=5e-06 lay_x=1.605775E-3 lay_y=2.697175E-3 sch_x=46.525287991E0 sch_y=78.14721467E0
 ebeam_wg_integral_1550_124  N$138 N$143 ebeam_wg_integral_1550 library="Design kits/EBeam" wg_length=0.000039247 wg_width=5e-07 points="[[1520.85,2710.7],[1530.85,2710.7],[1530.85,2728.35],[1545.55,2728.35]]" radius=5e-06 lay_x=1.5332E-3 lay_y=2.719525E-3 sch_x=44.422519685E0 sch_y=78.794777489E0
 ebeam_wg_integral_1550_125  N$144 N$141 ebeam_wg_integral_1550 library="Design kits/EBeam" wg_length=0.000039697 wg_width=5e-07 points="[[1665.55,2728.35],[1680.7,2728.35],[1680.7,2710.7],[1690.7,2710.7]]" radius=5e-06 lay_x=1.678125E-3 lay_y=2.719525E-3 sch_x=48.621537208E0 sch_y=78.794777489E0
 ebeam_bdc_te1550_126  N$146 N$130 N$134 N$145 ebeam_bdc_te1550 library="Design kits/ebeam"  lay_x=1.224725E-3 lay_y=2.60335E-3 sch_x=35.484848957E0 sch_y=75.428754645E0  sch_r=180 sch_f=true
 ebeam_y_1550_127  N$142 N$147 N$148 ebeam_y_1550 library="Design kits/ebeam"  lay_x=1.76885E-3 lay_y=2.706E-3 sch_x=51.250178675E0 sch_y=78.402907819E0
 ebeam_wg_integral_1550_128  N$147 N$148 ebeam_wg_integral_1550 library="Design kits/EBeam" wg_length=0.000120390 wg_width=5e-07 points="[[1776.25,2708.75],[1788.85,2708.75],[1788.85,2721.0],[1813.85,2721.0],[1813.85,2691.0],[1788.85,2691.0],[1788.85,2703.25],[1776.25,2703.25]]" radius=5e-06 lay_x=1.795425E-3 lay_y=2.706E-3 sch_x=52.020155496E0 sch_y=78.402907819E0
 ebeam_wg_integral_1550_129  N$135 N$149 ebeam_wg_integral_1550 library="Design kits/EBeam" wg_length=0.000396350 wg_width=5e-07 points="[[1380.1,2601.0],[1776.45,2601.0]]" radius=5e-06 lay_x=1.578275E-3 lay_y=2.601E-3 sch_x=45.728510472E0 sch_y=75.360666385E0
 ebeam_y_1550_130  N$149 N$150 N$151 ebeam_y_1550 library="Design kits/ebeam"  lay_x=1.78385E-3 lay_y=2.601E-3 sch_x=51.684784595E0 sch_y=75.360666385E0
 ebeam_wg_integral_1550_131  N$150 N$151 ebeam_wg_integral_1550 library="Design kits/EBeam" wg_length=0.000120390 wg_width=5e-07 points="[[1791.25,2603.75],[1803.85,2603.75],[1803.85,2616.0],[1828.85,2616.0],[1828.85,2586.0],[1803.85,2586.0],[1803.85,2598.25],[1791.25,2598.25]]" radius=5e-06 lay_x=1.810425E-3 lay_y=2.601E-3 sch_x=52.454761415E0 sch_y=75.360666385E0
 wg_heater_132  wg_heater_132_elec1 wg_heater_132_elec2 N$129 N$131 wg_heater library="Design kits/EBeam" wg_length=120.000u lay_x=1.1042E-3 lay_y=2.62335E-3 sch_x=31.992790397E0 sch_y=76.008229204E0  sch_r=180 sch_f=true
 ebeam_terminator_te1550_133  N$132 ebeam_terminator_te1550 library="Design kits/ebeam"  lay_x=943.3E-6 lay_y=2.6057E-3 sch_x=27.33091757E0 sch_y=75.496842906E0  sch_r=180 sch_f=true
 ebeam_terminator_te1550_134  N$145 ebeam_terminator_te1550 library="Design kits/ebeam"  lay_x=1.26555E-3 lay_y=2.6057E-3 sch_x=36.667701401E0 sch_y=75.496842906E0  sch_f=true
 ebeam_wg_integral_1550_135  N$133 N$146 ebeam_wg_integral_1550 library="Design kits/EBeam" wg_length=0.000198943 wg_width=5e-07 points="[[1019.5,2601.0],[1029.5,2601.0],[1029.5,2583.35],[1179.35,2583.35],[1179.35,2601.0],[1189.35,2601.0]]" radius=5e-06 lay_x=1.104425E-3 lay_y=2.592175E-3 sch_x=31.999309486E0 sch_y=75.104973236E0
 ebeam_wg_integral_1550_136  N$152 N$153 ebeam_wg_integral_1550 library="Design kits/EBeam" wg_length=0.000171597 wg_width=5e-07 points="[[678.75,2583.5],[753.3,2583.5],[753.3,2643.65],[793.3,2643.65]]" radius=5e-06 lay_x=736.025E-6 lay_y=2.613575E-3 sch_x=21.325388111E0 sch_y=75.725011014E0
 ebeam_wg_integral_1550_137  N$155 N$154 ebeam_wg_integral_1550 library="Design kits/EBeam" wg_length=0.000786847 wg_width=5e-07 points="[[793.3,2648.35],[781.3,2648.35],[781.3,2765.0],[120.0,2765.0]]" radius=5e-06 lay_x=456.65E-6 lay_y=2.706675E-3 sch_x=13.230852866E0 sch_y=78.422465085E0
 GC_TE_1550_8degOxide_BB_138  GC_TE_1550_8degOxide_BB_detector2 N$156 GC_TE_1550_8degOxide_BB library="Design kits/ebeam"  lay_x=100.015E-6 lay_y=2.511084E-3 sch_x=2.8978074E0 sch_y=72.755464663E0
 GC_TE_1550_8degOxide_BB_139  GC_TE_1550_8degOxide_BB_laser N$157 GC_TE_1550_8degOxide_BB library="Design kits/ebeam"  lay_x=100.015E-6 lay_y=2.638084E-3 sch_x=2.8978074E0 sch_y=76.435128112E0
 GC_TE_1550_8degOxide_BB_140  GC_TE_1550_8degOxide_BB_detector1 N$154 GC_TE_1550_8degOxide_BB library="Design kits/ebeam"  lay_x=100.015E-6 lay_y=2.765084E-3 sch_x=2.8978074E0 sch_y=80.114791561E0
 ebeam_bdc_te1550_141  N$161 N$158 N$159 N$160 ebeam_bdc_te1550 library="Design kits/ebeam"  lay_x=475.975E-6 lay_y=2.51335E-3 sch_x=13.790770159E0 sch_y=72.82111913E0  sch_r=180
 ebeam_bdc_te1550_142  N$163 N$164 N$165 N$162 ebeam_bdc_te1550 library="Design kits/ebeam"  lay_x=235.375E-6 lay_y=2.51335E-3 sch_x=6.819691215E0 sch_y=72.82111913E0  sch_r=180
 wg_heater_143  wg_heater_143_elec1 wg_heater_143_elec2 N$166 N$167 wg_heater library="Design kits/EBeam" wg_length=120.000u lay_x=355.9E-6 lay_y=2.53335E-3 sch_x=10.311749776E0 sch_y=73.400593689E0  sch_r=180
 ebeam_terminator_te1550_144  N$158 ebeam_terminator_te1550 library="Design kits/ebeam"  lay_x=516.8E-6 lay_y=2.5157E-3 sch_x=14.973622602E0 sch_y=72.889207391E0  sch_r=180
 ebeam_terminator_te1550_145  N$162 ebeam_terminator_te1550 library="Design kits/ebeam"  lay_x=194.55E-6 lay_y=2.5157E-3 sch_x=5.636838772E0 sch_y=72.889207391E0
 ebeam_wg_integral_1550_146  N$159 N$163 ebeam_wg_integral_1550 library="Design kits/EBeam" wg_length=0.000198943 wg_width=5e-07 points="[[440.6,2511.0],[430.6,2511.0],[430.6,2493.35],[280.75,2493.35],[280.75,2511.0],[270.75,2511.0]]" radius=5e-06 lay_x=355.675E-6 lay_y=2.502175E-3 sch_x=10.305230687E0 sch_y=72.497337721E0
 ebeam_wg_integral_1550_147  N$160 N$166 ebeam_wg_integral_1550 library="Design kits/EBeam" wg_length=0.000039247 wg_width=5e-07 points="[[440.6,2515.7],[430.6,2515.7],[430.6,2533.35],[415.9,2533.35]]" radius=5e-06 lay_x=428.25E-6 lay_y=2.524525E-3 sch_x=12.407998992E0 sch_y=73.14490054E0
 ebeam_wg_integral_1550_148  N$167 N$164 ebeam_wg_integral_1550 library="Design kits/EBeam" wg_length=0.000039697 wg_width=5e-07 points="[[295.9,2533.35],[280.75,2533.35],[280.75,2515.7],[270.75,2515.7]]" radius=5e-06 lay_x=283.325E-6 lay_y=2.524525E-3 sch_x=8.20898147E0 sch_y=73.14490054E0
 ebeam_wg_integral_1550_149  N$156 N$165 ebeam_wg_integral_1550 library="Design kits/EBeam" wg_length=0.000080000 wg_width=5e-07 points="[[120.0,2511.0],[200.0,2511.0]]" radius=5e-06 lay_x=160.0E-6 lay_y=2.511E-3 sch_x=4.635796471E0 sch_y=72.75303087E0
 ebeam_bdc_te1550_150  N$171 N$168 N$169 N$170 ebeam_bdc_te1550 library="Design kits/ebeam"  lay_x=475.975E-6 lay_y=2.38635E-3 sch_x=13.790770159E0 sch_y=69.141455681E0  sch_r=180
 ebeam_bdc_te1550_151  N$173 N$174 N$175 N$172 ebeam_bdc_te1550 library="Design kits/ebeam"  lay_x=235.375E-6 lay_y=2.38635E-3 sch_x=6.819691215E0 sch_y=69.141455681E0  sch_r=180
 wg_heater_152  wg_heater_152_elec1 wg_heater_152_elec2 N$176 N$177 wg_heater library="Design kits/EBeam" wg_length=120.000u lay_x=355.9E-6 lay_y=2.40635E-3 sch_x=10.311749776E0 sch_y=69.72093024E0  sch_r=180
 ebeam_terminator_te1550_153  N$168 ebeam_terminator_te1550 library="Design kits/ebeam"  lay_x=516.8E-6 lay_y=2.3887E-3 sch_x=14.973622602E0 sch_y=69.209543942E0  sch_r=180
 ebeam_terminator_te1550_154  N$172 ebeam_terminator_te1550 library="Design kits/ebeam"  lay_x=194.55E-6 lay_y=2.3887E-3 sch_x=5.636838772E0 sch_y=69.209543942E0
 ebeam_wg_integral_1550_155  N$169 N$173 ebeam_wg_integral_1550 library="Design kits/EBeam" wg_length=0.000198943 wg_width=5e-07 points="[[440.6,2384.0],[430.6,2384.0],[430.6,2366.35],[280.75,2366.35],[280.75,2384.0],[270.75,2384.0]]" radius=5e-06 lay_x=355.675E-6 lay_y=2.375175E-3 sch_x=10.305230687E0 sch_y=68.817674272E0
 ebeam_wg_integral_1550_156  N$170 N$176 ebeam_wg_integral_1550 library="Design kits/EBeam" wg_length=0.000039247 wg_width=5e-07 points="[[440.6,2388.7],[430.6,2388.7],[430.6,2406.35],[415.9,2406.35]]" radius=5e-06 lay_x=428.25E-6 lay_y=2.397525E-3 sch_x=12.407998992E0 sch_y=69.465237091E0
 ebeam_wg_integral_1550_157  N$177 N$174 ebeam_wg_integral_1550 library="Design kits/EBeam" wg_length=0.000039697 wg_width=5e-07 points="[[295.9,2406.35],[280.75,2406.35],[280.75,2388.7],[270.75,2388.7]]" radius=5e-06 lay_x=283.325E-6 lay_y=2.397525E-3 sch_x=8.20898147E0 sch_y=69.465237091E0
 ebeam_wg_integral_1550_158  N$178 N$175 ebeam_wg_integral_1550 library="Design kits/EBeam" wg_length=0.000080000 wg_width=5e-07 points="[[120.0,2384.0],[200.0,2384.0]]" radius=5e-06 lay_x=160.0E-6 lay_y=2.384E-3 sch_x=4.635796471E0 sch_y=69.073367421E0
 ebeam_y_1550_159  N$179 N$181 N$180 ebeam_y_1550 library="Design kits/ebeam"  lay_x=581.35E-6 lay_y=2.578E-3 sch_x=16.843876741E0 sch_y=74.694270642E0
 ebeam_y_1550_160  N$182 N$152 N$183 ebeam_y_1550 library="Design kits/ebeam"  lay_x=671.35E-6 lay_y=2.58075E-3 sch_x=19.451512256E0 sch_y=74.773948394E0
 ebeam_wg_integral_1550_161  N$157 N$179 ebeam_wg_integral_1550 library="Design kits/EBeam" wg_length=0.000510847 wg_width=5e-07 points="[[120.0,2638.0],[543.95,2638.0],[543.95,2578.0],[573.95,2578.0]]" radius=5e-06 lay_x=346.975E-6 lay_y=2.608E-3 sch_x=10.053159254E0 sch_y=75.56348248E0
 ebeam_wg_integral_1550_162  N$180 N$161 ebeam_wg_integral_1550 library="Design kits/EBeam" wg_length=0.000158547 wg_width=5e-07 points="[[588.75,2575.25],[598.75,2575.25],[598.75,2511.0],[511.35,2511.0]]" radius=5e-06 lay_x=555.425E-6 lay_y=2.543125E-3 sch_x=16.092732844E0 sch_y=73.68381188E0
 ebeam_wg_integral_1550_163  N$181 N$182 ebeam_wg_integral_1550 library="Design kits/EBeam" wg_length=0.000075200 wg_width=5e-07 points="[[588.75,2580.75],[663.95,2580.75]]" radius=5e-06 lay_x=626.35E-6 lay_y=2.58075E-3 sch_x=18.147694498E0 sch_y=74.773948394E0
 ebeam_wg_integral_1550_164  N$183 N$171 ebeam_wg_integral_1550 library="Design kits/EBeam" wg_length=0.000378297 wg_width=5e-07 points="[[678.75,2578.0],[688.75,2578.0],[688.75,2384.0],[511.35,2384.0]]" radius=5e-06 lay_x=600.425E-6 lay_y=2.481E-3 sch_x=17.396550601E0 sch_y=71.883819031E0
 ebeam_bdc_te1550_165  N$153 N$155 N$121 N$123 ebeam_bdc_te1550 library="Design kits/ebeam"  lay_x=828.675E-6 lay_y=2.646E-3 sch_x=24.009804005E0 sch_y=76.664484142E0  sch_r=180 sch_f=true
 GC_TE_1550_8degOxide_BB_166  GC_TE_1550_8degOxide_BB_detector3 N$178 GC_TE_1550_8degOxide_BB library="Design kits/ebeam"  lay_x=100.015E-6 lay_y=2.384084E-3 sch_x=2.8978074E0 sch_y=69.075801214E0
.ends EBeam_heaters_atharvdubey_ALU4

EBeam_heaters_atharvdubey_ALU4  wg_heater_117_elec1 wg_heater_117_elec2 wg_heater_120_elec1 wg_heater_120_elec2 wg_heater_132_elec1 wg_heater_132_elec2 wg_heater_143_elec1 wg_heater_143_elec2 wg_heater_152_elec1 wg_heater_152_elec2  GC_TE_1550_8degOxide_BB_detector2 GC_TE_1550_8degOxide_BB_laser GC_TE_1550_8degOxide_BB_detector1 GC_TE_1550_8degOxide_BB_detector3 EBeam_heaters_atharvdubey_ALU4 sch_x=-1 sch_y=-1 sch_r=270
