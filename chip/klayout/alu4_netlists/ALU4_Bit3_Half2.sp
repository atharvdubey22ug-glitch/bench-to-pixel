* Spice output from KLayout SiEPIC-Tools v0.5.31, 2026-10-15 13:02:26.

.subckt EBeam_heaters_atharvdubey_ALU4 wg_heater_59_elec1 wg_heater_59_elec2 wg_heater_68_elec1 wg_heater_68_elec2 wg_heater_91_elec1 wg_heater_91_elec2 wg_heater_97_elec1 wg_heater_97_elec2 wg_heater_109_elec1 wg_heater_109_elec2 GC_TE_1550_8degOxide_BB_detector3 GC_TE_1550_8degOxide_BB_detector2 GC_TE_1550_8degOxide_BB_laser GC_TE_1550_8degOxide_BB_detector1
.param MC_uniformity_width=0
.param MC_uniformity_thickness=0
.param MC_resolution_x=100
.param MC_resolution_y=100
.param MC_grid=10e-6
.param MC_non_uniform=0
 ebeam_terminator_te1550_3  N$5 ebeam_terminator_te1550 library="Design kits/ebeam"  lay_x=2.7933E-3 lay_y=1.8437E-3 sch_x=80.932314269E0 sch_y=53.418862212E0  sch_r=180 sch_f=true
 ebeam_wg_integral_1550_4  N$6 N$7 ebeam_wg_integral_1550 library="Design kits/EBeam" wg_length=0.000124247 wg_width=5e-07 points="[[2714.05,1881.65],[2756.4,1881.65],[2756.4,1839.0],[2798.75,1839.0]]" radius=5e-06 lay_x=2.7564E-3 lay_y=1.860325E-3 sch_x=79.863183707E0 sch_y=53.900550439E0
 ebeam_wg_integral_1550_5  N$8 N$9 ebeam_wg_integral_1550 library="Design kits/EBeam" wg_length=0.000640597 wg_width=5e-07 points="[[2714.05,1886.35],[2740.05,1886.35],[2740.05,1944.0],[3300.1,1944.0]]" radius=5e-06 lay_x=3.007075E-3 lay_y=1.915175E-3 sch_x=87.12617296E0 sch_y=55.489759417E0
 ebeam_bdc_te1550_58  N$66 N$67 N$68 N$65 ebeam_bdc_te1550 library="Design kits/ebeam"  lay_x=2.085375E-3 lay_y=1.75135E-3 sch_x=60.421087913E0 sch_y=50.743138436E0  sch_r=180
 wg_heater_59  wg_heater_59_elec1 wg_heater_59_elec2 N$69 N$70 wg_heater library="Design kits/EBeam" wg_length=120.000u lay_x=2.2059E-3 lay_y=1.77135E-3 sch_x=63.913146474E0 sch_y=51.322612995E0  sch_r=180
 ebeam_terminator_te1550_60  N$71 ebeam_terminator_te1550 library="Design kits/ebeam"  lay_x=2.3668E-3 lay_y=1.7537E-3 sch_x=68.5750193E0 sch_y=50.811226697E0  sch_r=180
 ebeam_terminator_te1550_61  N$65 ebeam_terminator_te1550 library="Design kits/ebeam"  lay_x=2.04455E-3 lay_y=1.7537E-3 sch_x=59.23823547E0 sch_y=50.811226697E0
 ebeam_wg_integral_1550_62  N$72 N$66 ebeam_wg_integral_1550 library="Design kits/EBeam" wg_length=0.000198943 wg_width=5e-07 points="[[2290.6,1749.0],[2280.6,1749.0],[2280.6,1731.35],[2130.75,1731.35],[2130.75,1749.0],[2120.75,1749.0]]" radius=5e-06 lay_x=2.205675E-3 lay_y=1.740175E-3 sch_x=63.906627385E0 sch_y=50.419357027E0
 ebeam_wg_integral_1550_63  N$73 N$69 ebeam_wg_integral_1550 library="Design kits/EBeam" wg_length=0.000039247 wg_width=5e-07 points="[[2290.6,1753.7],[2280.6,1753.7],[2280.6,1771.35],[2265.9,1771.35]]" radius=5e-06 lay_x=2.27825E-3 lay_y=1.762525E-3 sch_x=66.009395691E0 sch_y=51.066919846E0
 ebeam_wg_integral_1550_64  N$70 N$67 ebeam_wg_integral_1550 library="Design kits/EBeam" wg_length=0.000039697 wg_width=5e-07 points="[[2145.9,1771.35],[2130.75,1771.35],[2130.75,1753.7],[2120.75,1753.7]]" radius=5e-06 lay_x=2.133325E-3 lay_y=1.762525E-3 sch_x=61.810378168E0 sch_y=51.066919846E0
 ebeam_wg_integral_1550_65  N$74 N$68 ebeam_wg_integral_1550 library="Design kits/EBeam" wg_length=0.000080000 wg_width=5e-07 points="[[1970.0,1749.0],[2050.0,1749.0]]" radius=5e-06 lay_x=2.01E-3 lay_y=1.749E-3 sch_x=58.237193169E0 sch_y=50.675050176E0
 ebeam_bdc_te1550_66  N$78 N$75 N$76 N$77 ebeam_bdc_te1550 library="Design kits/ebeam"  lay_x=2.325975E-3 lay_y=1.62435E-3 sch_x=67.392166857E0 sch_y=47.063474987E0  sch_r=180
 ebeam_bdc_te1550_67  N$80 N$81 N$82 N$79 ebeam_bdc_te1550 library="Design kits/ebeam"  lay_x=2.085375E-3 lay_y=1.62435E-3 sch_x=60.421087913E0 sch_y=47.063474987E0  sch_r=180
 wg_heater_68  wg_heater_68_elec1 wg_heater_68_elec2 N$83 N$84 wg_heater library="Design kits/EBeam" wg_length=120.000u lay_x=2.2059E-3 lay_y=1.64435E-3 sch_x=63.913146474E0 sch_y=47.642949546E0  sch_r=180
 ebeam_terminator_te1550_69  N$75 ebeam_terminator_te1550 library="Design kits/ebeam"  lay_x=2.3668E-3 lay_y=1.6267E-3 sch_x=68.5750193E0 sch_y=47.131563248E0  sch_r=180
 ebeam_terminator_te1550_70  N$79 ebeam_terminator_te1550 library="Design kits/ebeam"  lay_x=2.04455E-3 lay_y=1.6267E-3 sch_x=59.23823547E0 sch_y=47.131563248E0
 ebeam_wg_integral_1550_71  N$76 N$80 ebeam_wg_integral_1550 library="Design kits/EBeam" wg_length=0.000198943 wg_width=5e-07 points="[[2290.6,1622.0],[2280.6,1622.0],[2280.6,1604.35],[2130.75,1604.35],[2130.75,1622.0],[2120.75,1622.0]]" radius=5e-06 lay_x=2.205675E-3 lay_y=1.613175E-3 sch_x=63.906627385E0 sch_y=46.739693578E0
 ebeam_wg_integral_1550_72  N$77 N$83 ebeam_wg_integral_1550 library="Design kits/EBeam" wg_length=0.000039247 wg_width=5e-07 points="[[2290.6,1626.7],[2280.6,1626.7],[2280.6,1644.35],[2265.9,1644.35]]" radius=5e-06 lay_x=2.27825E-3 lay_y=1.635525E-3 sch_x=66.009395691E0 sch_y=47.387256397E0
 ebeam_wg_integral_1550_73  N$84 N$81 ebeam_wg_integral_1550 library="Design kits/EBeam" wg_length=0.000039697 wg_width=5e-07 points="[[2145.9,1644.35],[2130.75,1644.35],[2130.75,1626.7],[2120.75,1626.7]]" radius=5e-06 lay_x=2.133325E-3 lay_y=1.635525E-3 sch_x=61.810378168E0 sch_y=47.387256397E0
 ebeam_wg_integral_1550_74  N$85 N$82 ebeam_wg_integral_1550 library="Design kits/EBeam" wg_length=0.000080000 wg_width=5e-07 points="[[1970.0,1622.0],[2050.0,1622.0]]" radius=5e-06 lay_x=2.01E-3 lay_y=1.622E-3 sch_x=58.237193169E0 sch_y=46.995386727E0
 ebeam_y_1550_75  N$86 N$88 N$87 ebeam_y_1550 library="Design kits/ebeam"  lay_x=2.43135E-3 lay_y=1.816E-3 sch_x=70.445273439E0 sch_y=52.616289948E0
 ebeam_y_1550_76  N$89 N$91 N$90 ebeam_y_1550 library="Design kits/ebeam"  lay_x=2.52135E-3 lay_y=1.81875E-3 sch_x=73.052908954E0 sch_y=52.6959677E0
 ebeam_wg_integral_1550_77  N$92 N$86 ebeam_wg_integral_1550 library="Design kits/EBeam" wg_length=0.000510847 wg_width=5e-07 points="[[1970.0,1876.0],[2393.95,1876.0],[2393.95,1816.0],[2423.95,1816.0]]" radius=5e-06 lay_x=2.196975E-3 lay_y=1.846E-3 sch_x=63.654555952E0 sch_y=53.485501786E0
 ebeam_wg_integral_1550_78  N$87 N$93 ebeam_wg_integral_1550 library="Design kits/EBeam" wg_length=0.000158547 wg_width=5e-07 points="[[2438.75,1813.25],[2448.75,1813.25],[2448.75,1749.0],[2361.35,1749.0]]" radius=5e-06 lay_x=2.405425E-3 lay_y=1.781125E-3 sch_x=69.694129542E0 sch_y=51.605831186E0
 ebeam_wg_integral_1550_79  N$88 N$89 ebeam_wg_integral_1550 library="Design kits/EBeam" wg_length=0.000075200 wg_width=5e-07 points="[[2438.75,1818.75],[2513.95,1818.75]]" radius=5e-06 lay_x=2.47635E-3 lay_y=1.81875E-3 sch_x=71.749091196E0 sch_y=52.6959677E0
 ebeam_wg_integral_1550_80  N$90 N$78 ebeam_wg_integral_1550 library="Design kits/EBeam" wg_length=0.000378297 wg_width=5e-07 points="[[2528.75,1816.0],[2538.75,1816.0],[2538.75,1622.0],[2361.35,1622.0]]" radius=5e-06 lay_x=2.450425E-3 lay_y=1.719E-3 sch_x=70.997947299E0 sch_y=49.805838337E0
 ebeam_bdc_te1550_81  N$94 N$95 N$6 N$8 ebeam_bdc_te1550 library="Design kits/ebeam"  lay_x=2.678675E-3 lay_y=1.884E-3 sch_x=77.611200703E0 sch_y=54.586503448E0  sch_r=180 sch_f=true
 ebeam_wg_integral_1550_82  N$91 N$94 ebeam_wg_integral_1550 library="Design kits/EBeam" wg_length=0.000171597 wg_width=5e-07 points="[[2528.75,1821.5],[2603.3,1821.5],[2603.3,1881.65],[2643.3,1881.65]]" radius=5e-06 lay_x=2.586025E-3 lay_y=1.851575E-3 sch_x=74.926784809E0 sch_y=53.64703032E0
 ebeam_wg_integral_1550_83  N$95 N$96 ebeam_wg_integral_1550 library="Design kits/EBeam" wg_length=0.000786847 wg_width=5e-07 points="[[2643.3,1886.35],[2631.3,1886.35],[2631.3,2003.0],[1970.0,2003.0]]" radius=5e-06 lay_x=2.30665E-3 lay_y=1.944675E-3 sch_x=66.832249564E0 sch_y=56.344484391E0
 GC_TE_1550_8degOxide_BB_84  GC_TE_1550_8degOxide_BB_detector3 N$85 GC_TE_1550_8degOxide_BB library="Design kits/ebeam"  lay_x=1.950015E-3 lay_y=1.622084E-3 sch_x=56.499204099E0 sch_y=46.99782052E0
 GC_TE_1550_8degOxide_BB_85  GC_TE_1550_8degOxide_BB_detector2 N$74 GC_TE_1550_8degOxide_BB library="Design kits/ebeam"  lay_x=1.950015E-3 lay_y=1.749084E-3 sch_x=56.499204099E0 sch_y=50.677483969E0
 GC_TE_1550_8degOxide_BB_86  GC_TE_1550_8degOxide_BB_laser N$92 GC_TE_1550_8degOxide_BB library="Design kits/ebeam"  lay_x=1.950015E-3 lay_y=1.876084E-3 sch_x=56.499204099E0 sch_y=54.357147418E0
 GC_TE_1550_8degOxide_BB_87  GC_TE_1550_8degOxide_BB_detector1 N$96 GC_TE_1550_8degOxide_BB library="Design kits/ebeam"  lay_x=1.950015E-3 lay_y=2.003084E-3 sch_x=56.499204099E0 sch_y=58.036810867E0
 ebeam_bdc_te1550_88  N$93 N$71 N$72 N$73 ebeam_bdc_te1550 library="Design kits/ebeam"  lay_x=2.325975E-3 lay_y=1.75135E-3 sch_x=67.392166857E0 sch_y=50.743138436E0  sch_r=180
 ebeam_bdc_te1550_89  N$9 N$97 N$98 N$99 ebeam_bdc_te1550 library="Design kits/ebeam"  lay_x=3.335475E-3 lay_y=1.94635E-3 sch_x=96.641145217E0 sch_y=56.393015386E0  sch_r=180 sch_f=true
 ebeam_bdc_te1550_90  N$101 N$102 N$103 N$100 ebeam_bdc_te1550 library="Design kits/ebeam"  lay_x=3.576075E-3 lay_y=1.94635E-3 sch_x=103.612224161E0 sch_y=56.393015386E0  sch_r=180 sch_f=true
 wg_heater_91  wg_heater_91_elec1 wg_heater_91_elec2 N$104 N$105 wg_heater library="Design kits/EBeam" wg_length=120.000u lay_x=3.45555E-3 lay_y=1.96635E-3 sch_x=100.1201656E0 sch_y=56.972489945E0  sch_r=180 sch_f=true
 ebeam_terminator_te1550_92  N$97 ebeam_terminator_te1550 library="Design kits/ebeam"  lay_x=3.29465E-3 lay_y=1.9487E-3 sch_x=95.458292774E0 sch_y=56.461103646E0  sch_r=180 sch_f=true
 ebeam_terminator_te1550_93  N$100 ebeam_terminator_te1550 library="Design kits/ebeam"  lay_x=3.6169E-3 lay_y=1.9487E-3 sch_x=104.795076604E0 sch_y=56.461103646E0  sch_f=true
 ebeam_wg_integral_1550_94  N$98 N$101 ebeam_wg_integral_1550 library="Design kits/EBeam" wg_length=0.000198943 wg_width=5e-07 points="[[3370.85,1944.0],[3380.85,1944.0],[3380.85,1926.35],[3530.7,1926.35],[3530.7,1944.0],[3540.7,1944.0]]" radius=5e-06 lay_x=3.455775E-3 lay_y=1.935175E-3 sch_x=100.126684689E0 sch_y=56.069233976E0
 ebeam_wg_integral_1550_95  N$99 N$104 ebeam_wg_integral_1550 library="Design kits/EBeam" wg_length=0.000039247 wg_width=5e-07 points="[[3370.85,1948.7],[3380.85,1948.7],[3380.85,1966.35],[3395.55,1966.35]]" radius=5e-06 lay_x=3.3832E-3 lay_y=1.957525E-3 sch_x=98.023916383E0 sch_y=56.716796795E0
 ebeam_wg_integral_1550_96  N$105 N$102 ebeam_wg_integral_1550 library="Design kits/EBeam" wg_length=0.000039697 wg_width=5e-07 points="[[3515.55,1966.35],[3530.7,1966.35],[3530.7,1948.7],[3540.7,1948.7]]" radius=5e-06 lay_x=3.528125E-3 lay_y=1.957525E-3 sch_x=102.222933906E0 sch_y=56.716796795E0
 wg_heater_97  wg_heater_97_elec1 wg_heater_97_elec2 N$106 N$107 wg_heater library="Design kits/EBeam" wg_length=120.000u lay_x=2.9542E-3 lay_y=1.86135E-3 sch_x=85.594187095E0 sch_y=53.93024851E0  sch_r=180 sch_f=true
 ebeam_y_1550_98  N$103 N$108 N$109 ebeam_y_1550 library="Design kits/ebeam"  lay_x=3.61885E-3 lay_y=1.944E-3 sch_x=104.851575373E0 sch_y=56.324927125E0
 ebeam_wg_integral_1550_99  N$108 N$109 ebeam_wg_integral_1550 library="Design kits/EBeam" wg_length=0.000120390 wg_width=5e-07 points="[[3626.25,1946.75],[3638.85,1946.75],[3638.85,1959.0],[3663.85,1959.0],[3663.85,1929.0],[3638.85,1929.0],[3638.85,1941.25],[3626.25,1941.25]]" radius=5e-06 lay_x=3.645425E-3 lay_y=1.944E-3 sch_x=105.621552194E0 sch_y=56.324927125E0
 ebeam_wg_integral_1550_100  N$111 N$110 ebeam_wg_integral_1550 library="Design kits/EBeam" wg_length=0.000396350 wg_width=5e-07 points="[[3230.1,1839.0],[3626.45,1839.0]]" radius=5e-06 lay_x=3.428275E-3 lay_y=1.839E-3 sch_x=99.32990717E0 sch_y=53.282685691E0
 ebeam_y_1550_101  N$110 N$112 N$113 ebeam_y_1550 library="Design kits/ebeam"  lay_x=3.63385E-3 lay_y=1.839E-3 sch_x=105.286181293E0 sch_y=53.282685691E0
 ebeam_wg_integral_1550_102  N$112 N$113 ebeam_wg_integral_1550 library="Design kits/EBeam" wg_length=0.000120390 wg_width=5e-07 points="[[3641.25,1841.75],[3653.85,1841.75],[3653.85,1854.0],[3678.85,1854.0],[3678.85,1824.0],[3653.85,1824.0],[3653.85,1836.25],[3641.25,1836.25]]" radius=5e-06 lay_x=3.660425E-3 lay_y=1.839E-3 sch_x=106.056158113E0 sch_y=53.282685691E0
 ebeam_bdc_te1550_103  N$7 N$5 N$114 N$115 ebeam_bdc_te1550 library="Design kits/ebeam"  lay_x=2.834125E-3 lay_y=1.84135E-3 sch_x=82.115166712E0 sch_y=53.350773951E0  sch_r=180 sch_f=true
 ebeam_terminator_te1550_104  N$116 ebeam_terminator_te1550 library="Design kits/ebeam"  lay_x=3.11555E-3 lay_y=1.8437E-3 sch_x=90.269098099E0 sch_y=53.418862212E0  sch_f=true
 ebeam_wg_integral_1550_105  N$114 N$117 ebeam_wg_integral_1550 library="Design kits/EBeam" wg_length=0.000198943 wg_width=5e-07 points="[[2869.5,1839.0],[2879.5,1839.0],[2879.5,1821.35],[3029.35,1821.35],[3029.35,1839.0],[3039.35,1839.0]]" radius=5e-06 lay_x=2.954425E-3 lay_y=1.830175E-3 sch_x=85.600706184E0 sch_y=53.026992542E0
 ebeam_wg_integral_1550_106  N$115 N$106 ebeam_wg_integral_1550 library="Design kits/EBeam" wg_length=0.000039247 wg_width=5e-07 points="[[2869.5,1843.7],[2879.5,1843.7],[2879.5,1861.35],[2894.2,1861.35]]" radius=5e-06 lay_x=2.88185E-3 lay_y=1.852525E-3 sch_x=83.497937878E0 sch_y=53.674555361E0
 ebeam_wg_integral_1550_107  N$107 N$118 ebeam_wg_integral_1550 library="Design kits/EBeam" wg_length=0.000039697 wg_width=5e-07 points="[[3014.2,1861.35],[3029.35,1861.35],[3029.35,1843.7],[3039.35,1843.7]]" radius=5e-06 lay_x=3.026775E-3 lay_y=1.852525E-3 sch_x=87.696955401E0 sch_y=53.674555361E0
 ebeam_bdc_te1550_108  N$117 N$118 N$119 N$116 ebeam_bdc_te1550 library="Design kits/ebeam"  lay_x=3.074725E-3 lay_y=1.84135E-3 sch_x=89.086245655E0 sch_y=53.350773951E0  sch_r=180 sch_f=true
 wg_heater_109  wg_heater_109_elec1 wg_heater_109_elec2 N$119 N$111 wg_heater library="Design kits/EBeam" wg_length=120.000u lay_x=3.1701E-3 lay_y=1.839E-3 sch_x=91.849614958E0 sch_y=53.282685691E0
.ends EBeam_heaters_atharvdubey_ALU4

EBeam_heaters_atharvdubey_ALU4  wg_heater_59_elec1 wg_heater_59_elec2 wg_heater_68_elec1 wg_heater_68_elec2 wg_heater_91_elec1 wg_heater_91_elec2 wg_heater_97_elec1 wg_heater_97_elec2 wg_heater_109_elec1 wg_heater_109_elec2  GC_TE_1550_8degOxide_BB_detector3 GC_TE_1550_8degOxide_BB_detector2 GC_TE_1550_8degOxide_BB_laser GC_TE_1550_8degOxide_BB_detector1 EBeam_heaters_atharvdubey_ALU4 sch_x=-1 sch_y=-1 sch_r=270
