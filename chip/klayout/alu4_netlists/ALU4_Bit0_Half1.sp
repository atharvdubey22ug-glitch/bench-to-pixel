* Spice output from KLayout SiEPIC-Tools v0.5.31, 2026-10-15 13:02:24.

.subckt EBeam_heaters_atharvdubey_ALU4 wg_heater_228_elec1 wg_heater_228_elec2 wg_heater_231_elec1 wg_heater_231_elec2 wg_heater_243_elec1 wg_heater_243_elec2 wg_heater_262_elec1 wg_heater_262_elec2 wg_heater_271_elec1 wg_heater_271_elec2 GC_TE_1550_8degOxide_BB_detector3 GC_TE_1550_8degOxide_BB_detector2 GC_TE_1550_8degOxide_BB_laser GC_TE_1550_8degOxide_BB_detector1
.param MC_uniformity_width=0
.param MC_uniformity_thickness=0
.param MC_resolution_x=100
.param MC_resolution_y=100
.param MC_grid=10e-6
.param MC_non_uniform=0
 ebeam_wg_integral_1550_220  N$241 N$240 ebeam_wg_integral_1550 library="Design kits/EBeam" wg_length=0.000124247 wg_width=5e-07 points="[[864.05,1119.65],[906.4,1119.65],[906.4,1077.0],[948.75,1077.0]]" radius=5e-06 lay_x=906.4E-6 lay_y=1.098325E-3 sch_x=26.261787009E0 sch_y=31.822569745E0
 ebeam_wg_integral_1550_221  N$243 N$242 ebeam_wg_integral_1550 library="Design kits/EBeam" wg_length=0.000640597 wg_width=5e-07 points="[[864.05,1124.35],[890.05,1124.35],[890.05,1182.0],[1450.1,1182.0]]" radius=5e-06 lay_x=1.157075E-3 lay_y=1.153175E-3 sch_x=33.524776262E0 sch_y=33.411778723E0
 ebeam_wg_integral_1550_224  N$248 N$249 ebeam_wg_integral_1550 library="Design kits/EBeam" wg_length=0.000198943 wg_width=5e-07 points="[[1019.5,1077.0],[1029.5,1077.0],[1029.5,1059.35],[1179.35,1059.35],[1179.35,1077.0],[1189.35,1077.0]]" radius=5e-06 lay_x=1.104425E-3 lay_y=1.068175E-3 sch_x=31.999309486E0 sch_y=30.949011848E0
 ebeam_wg_integral_1550_225  N$250 N$251 ebeam_wg_integral_1550 library="Design kits/EBeam" wg_length=0.000039247 wg_width=5e-07 points="[[1019.5,1081.7],[1029.5,1081.7],[1029.5,1099.35],[1044.2,1099.35]]" radius=5e-06 lay_x=1.03185E-3 lay_y=1.090525E-3 sch_x=29.89654118E0 sch_y=31.596574667E0
 ebeam_wg_integral_1550_226  N$253 N$252 ebeam_wg_integral_1550 library="Design kits/EBeam" wg_length=0.000039697 wg_width=5e-07 points="[[1164.2,1099.35],[1179.35,1099.35],[1179.35,1081.7],[1189.35,1081.7]]" radius=5e-06 lay_x=1.176775E-3 lay_y=1.090525E-3 sch_x=34.095558702E0 sch_y=31.596574667E0
 ebeam_bdc_te1550_227  N$240 N$254 N$248 N$250 ebeam_bdc_te1550 library="Design kits/ebeam"  lay_x=984.125E-6 lay_y=1.07935E-3 sch_x=28.513770014E0 sch_y=31.272793257E0  sch_r=180 sch_f=true
 wg_heater_228  wg_heater_228_elec1 wg_heater_228_elec2 N$255 N$256 wg_heater library="Design kits/EBeam" wg_length=120.000u lay_x=1.3201E-3 lay_y=1.077E-3 sch_x=38.24821826E0 sch_y=31.204704997E0
 ebeam_bdc_te1550_229  N$242 N$257 N$258 N$259 ebeam_bdc_te1550 library="Design kits/ebeam"  lay_x=1.485475E-3 lay_y=1.18435E-3 sch_x=43.039748519E0 sch_y=34.315034692E0  sch_r=180 sch_f=true
 ebeam_bdc_te1550_230  N$261 N$262 N$263 N$260 ebeam_bdc_te1550 library="Design kits/ebeam"  lay_x=1.726075E-3 lay_y=1.18435E-3 sch_x=50.010827463E0 sch_y=34.315034692E0  sch_r=180 sch_f=true
 wg_heater_231  wg_heater_231_elec1 wg_heater_231_elec2 N$264 N$265 wg_heater library="Design kits/EBeam" wg_length=120.000u lay_x=1.60555E-3 lay_y=1.20435E-3 sch_x=46.518768902E0 sch_y=34.89450925E0  sch_r=180 sch_f=true
 ebeam_terminator_te1550_232  N$257 ebeam_terminator_te1550 library="Design kits/ebeam"  lay_x=1.44465E-3 lay_y=1.1867E-3 sch_x=41.856896076E0 sch_y=34.383122952E0  sch_r=180 sch_f=true
 ebeam_terminator_te1550_233  N$260 ebeam_terminator_te1550 library="Design kits/ebeam"  lay_x=1.7669E-3 lay_y=1.1867E-3 sch_x=51.193679906E0 sch_y=34.383122952E0  sch_f=true
 ebeam_wg_integral_1550_234  N$258 N$261 ebeam_wg_integral_1550 library="Design kits/EBeam" wg_length=0.000198943 wg_width=5e-07 points="[[1520.85,1182.0],[1530.85,1182.0],[1530.85,1164.35],[1680.7,1164.35],[1680.7,1182.0],[1690.7,1182.0]]" radius=5e-06 lay_x=1.605775E-3 lay_y=1.173175E-3 sch_x=46.525287991E0 sch_y=33.991253282E0
 ebeam_wg_integral_1550_235  N$259 N$264 ebeam_wg_integral_1550 library="Design kits/EBeam" wg_length=0.000039247 wg_width=5e-07 points="[[1520.85,1186.7],[1530.85,1186.7],[1530.85,1204.35],[1545.55,1204.35]]" radius=5e-06 lay_x=1.5332E-3 lay_y=1.195525E-3 sch_x=44.422519685E0 sch_y=34.638816101E0
 ebeam_wg_integral_1550_236  N$265 N$262 ebeam_wg_integral_1550 library="Design kits/EBeam" wg_length=0.000039697 wg_width=5e-07 points="[[1665.55,1204.35],[1680.7,1204.35],[1680.7,1186.7],[1690.7,1186.7]]" radius=5e-06 lay_x=1.678125E-3 lay_y=1.195525E-3 sch_x=48.621537208E0 sch_y=34.638816101E0
 ebeam_bdc_te1550_237  N$249 N$252 N$255 N$266 ebeam_bdc_te1550 library="Design kits/ebeam"  lay_x=1.224725E-3 lay_y=1.07935E-3 sch_x=35.484848957E0 sch_y=31.272793257E0  sch_r=180 sch_f=true
 ebeam_y_1550_238  N$263 N$267 N$268 ebeam_y_1550 library="Design kits/ebeam"  lay_x=1.76885E-3 lay_y=1.182E-3 sch_x=51.250178675E0 sch_y=34.246946431E0
 ebeam_wg_integral_1550_239  N$267 N$268 ebeam_wg_integral_1550 library="Design kits/EBeam" wg_length=0.000120390 wg_width=5e-07 points="[[1776.25,1184.75],[1788.85,1184.75],[1788.85,1197.0],[1813.85,1197.0],[1813.85,1167.0],[1788.85,1167.0],[1788.85,1179.25],[1776.25,1179.25]]" radius=5e-06 lay_x=1.795425E-3 lay_y=1.182E-3 sch_x=52.020155496E0 sch_y=34.246946431E0
 ebeam_wg_integral_1550_240  N$256 N$269 ebeam_wg_integral_1550 library="Design kits/EBeam" wg_length=0.000396350 wg_width=5e-07 points="[[1380.1,1077.0],[1776.45,1077.0]]" radius=5e-06 lay_x=1.578275E-3 lay_y=1.077E-3 sch_x=45.728510472E0 sch_y=31.204704997E0
 ebeam_y_1550_241  N$269 N$270 N$271 ebeam_y_1550 library="Design kits/ebeam"  lay_x=1.78385E-3 lay_y=1.077E-3 sch_x=51.684784595E0 sch_y=31.204704997E0
 ebeam_wg_integral_1550_242  N$270 N$271 ebeam_wg_integral_1550 library="Design kits/EBeam" wg_length=0.000120390 wg_width=5e-07 points="[[1791.25,1079.75],[1803.85,1079.75],[1803.85,1092.0],[1828.85,1092.0],[1828.85,1062.0],[1803.85,1062.0],[1803.85,1074.25],[1791.25,1074.25]]" radius=5e-06 lay_x=1.810425E-3 lay_y=1.077E-3 sch_x=52.454761415E0 sch_y=31.204704997E0
 wg_heater_243  wg_heater_243_elec1 wg_heater_243_elec2 N$251 N$253 wg_heater library="Design kits/EBeam" wg_length=120.000u lay_x=1.1042E-3 lay_y=1.09935E-3 sch_x=31.992790397E0 sch_y=31.852267816E0  sch_r=180 sch_f=true
 ebeam_terminator_te1550_244  N$254 ebeam_terminator_te1550 library="Design kits/ebeam"  lay_x=943.3E-6 lay_y=1.0817E-3 sch_x=27.33091757E0 sch_y=31.340881518E0  sch_r=180 sch_f=true
 ebeam_terminator_te1550_245  N$266 ebeam_terminator_te1550 library="Design kits/ebeam"  lay_x=1.26555E-3 lay_y=1.0817E-3 sch_x=36.667701401E0 sch_y=31.340881518E0  sch_f=true
 ebeam_wg_integral_1550_246  N$272 N$273 ebeam_wg_integral_1550 library="Design kits/EBeam" wg_length=0.000510847 wg_width=5e-07 points="[[120.0,1114.0],[543.95,1114.0],[543.95,1054.0],[573.95,1054.0]]" radius=5e-06 lay_x=346.975E-6 lay_y=1.084E-3 sch_x=10.053159254E0 sch_y=31.407521092E0
 ebeam_wg_integral_1550_247  N$275 N$274 ebeam_wg_integral_1550 library="Design kits/EBeam" wg_length=0.000158547 wg_width=5e-07 points="[[588.75,1051.25],[598.75,1051.25],[598.75,987.0],[511.35,987.0]]" radius=5e-06 lay_x=555.425E-6 lay_y=1.019125E-3 sch_x=16.092732844E0 sch_y=29.527850492E0
 ebeam_wg_integral_1550_248  N$276 N$277 ebeam_wg_integral_1550 library="Design kits/EBeam" wg_length=0.000075200 wg_width=5e-07 points="[[588.75,1056.75],[663.95,1056.75]]" radius=5e-06 lay_x=626.35E-6 lay_y=1.05675E-3 sch_x=18.147694498E0 sch_y=30.617987006E0
 ebeam_wg_integral_1550_249  N$279 N$278 ebeam_wg_integral_1550 library="Design kits/EBeam" wg_length=0.000378297 wg_width=5e-07 points="[[678.75,1054.0],[688.75,1054.0],[688.75,860.0],[511.35,860.0]]" radius=5e-06 lay_x=600.425E-6 lay_y=957.0E-6 sch_x=17.396550601E0 sch_y=27.727857643E0
 ebeam_bdc_te1550_250  N$280 N$281 N$241 N$243 ebeam_bdc_te1550 library="Design kits/ebeam"  lay_x=828.675E-6 lay_y=1.122E-3 sch_x=24.009804005E0 sch_y=32.508522754E0  sch_r=180 sch_f=true
 ebeam_wg_integral_1550_251  N$282 N$280 ebeam_wg_integral_1550 library="Design kits/EBeam" wg_length=0.000171597 wg_width=5e-07 points="[[678.75,1059.5],[753.3,1059.5],[753.3,1119.65],[793.3,1119.65]]" radius=5e-06 lay_x=736.025E-6 lay_y=1.089575E-3 sch_x=21.325388111E0 sch_y=31.569049626E0
 ebeam_wg_integral_1550_252  N$281 N$283 ebeam_wg_integral_1550 library="Design kits/EBeam" wg_length=0.000786847 wg_width=5e-07 points="[[793.3,1124.35],[781.3,1124.35],[781.3,1241.0],[120.0,1241.0]]" radius=5e-06 lay_x=456.65E-6 lay_y=1.182675E-3 sch_x=13.230852866E0 sch_y=34.266503697E0
 GC_TE_1550_8degOxide_BB_256  GC_TE_1550_8degOxide_BB_detector3 N$286 GC_TE_1550_8degOxide_BB library="Design kits/ebeam"  lay_x=100.015E-6 lay_y=860.084E-6 sch_x=2.8978074E0 sch_y=24.919839826E0
 GC_TE_1550_8degOxide_BB_257  GC_TE_1550_8degOxide_BB_detector2 N$287 GC_TE_1550_8degOxide_BB library="Design kits/ebeam"  lay_x=100.015E-6 lay_y=987.084E-6 sch_x=2.8978074E0 sch_y=28.599503275E0
 GC_TE_1550_8degOxide_BB_258  GC_TE_1550_8degOxide_BB_laser N$272 GC_TE_1550_8degOxide_BB library="Design kits/ebeam"  lay_x=100.015E-6 lay_y=1.114084E-3 sch_x=2.8978074E0 sch_y=32.279166724E0
 GC_TE_1550_8degOxide_BB_259  GC_TE_1550_8degOxide_BB_detector1 N$283 GC_TE_1550_8degOxide_BB library="Design kits/ebeam"  lay_x=100.015E-6 lay_y=1.241084E-3 sch_x=2.8978074E0 sch_y=35.958830173E0
 ebeam_bdc_te1550_260  N$274 N$288 N$289 N$290 ebeam_bdc_te1550 library="Design kits/ebeam"  lay_x=475.975E-6 lay_y=989.35E-6 sch_x=13.790770159E0 sch_y=28.665157742E0  sch_r=180
 ebeam_bdc_te1550_261  N$292 N$293 N$294 N$291 ebeam_bdc_te1550 library="Design kits/ebeam"  lay_x=235.375E-6 lay_y=989.35E-6 sch_x=6.819691215E0 sch_y=28.665157742E0  sch_r=180
 wg_heater_262  wg_heater_262_elec1 wg_heater_262_elec2 N$295 N$296 wg_heater library="Design kits/EBeam" wg_length=120.000u lay_x=355.9E-6 lay_y=1.00935E-3 sch_x=10.311749776E0 sch_y=29.244632301E0  sch_r=180
 ebeam_terminator_te1550_263  N$288 ebeam_terminator_te1550 library="Design kits/ebeam"  lay_x=516.8E-6 lay_y=991.7E-6 sch_x=14.973622602E0 sch_y=28.733246003E0  sch_r=180
 ebeam_terminator_te1550_264  N$291 ebeam_terminator_te1550 library="Design kits/ebeam"  lay_x=194.55E-6 lay_y=991.7E-6 sch_x=5.636838772E0 sch_y=28.733246003E0
 ebeam_wg_integral_1550_265  N$289 N$292 ebeam_wg_integral_1550 library="Design kits/EBeam" wg_length=0.000198943 wg_width=5e-07 points="[[440.6,987.0],[430.6,987.0],[430.6,969.35],[280.75,969.35],[280.75,987.0],[270.75,987.0]]" radius=5e-06 lay_x=355.675E-6 lay_y=978.175E-6 sch_x=10.305230687E0 sch_y=28.341376333E0
 ebeam_wg_integral_1550_266  N$290 N$295 ebeam_wg_integral_1550 library="Design kits/EBeam" wg_length=0.000039247 wg_width=5e-07 points="[[440.6,991.7],[430.6,991.7],[430.6,1009.35],[415.9,1009.35]]" radius=5e-06 lay_x=428.25E-6 lay_y=1.000525E-3 sch_x=12.407998992E0 sch_y=28.988939152E0
 ebeam_wg_integral_1550_267  N$296 N$293 ebeam_wg_integral_1550 library="Design kits/EBeam" wg_length=0.000039697 wg_width=5e-07 points="[[295.9,1009.35],[280.75,1009.35],[280.75,991.7],[270.75,991.7]]" radius=5e-06 lay_x=283.325E-6 lay_y=1.000525E-3 sch_x=8.20898147E0 sch_y=28.988939152E0
 ebeam_wg_integral_1550_268  N$287 N$294 ebeam_wg_integral_1550 library="Design kits/EBeam" wg_length=0.000080000 wg_width=5e-07 points="[[120.0,987.0],[200.0,987.0]]" radius=5e-06 lay_x=160.0E-6 lay_y=987.0E-6 sch_x=4.635796471E0 sch_y=28.597069482E0
 ebeam_bdc_te1550_269  N$278 N$297 N$298 N$299 ebeam_bdc_te1550 library="Design kits/ebeam"  lay_x=475.975E-6 lay_y=862.35E-6 sch_x=13.790770159E0 sch_y=24.985494293E0  sch_r=180
 ebeam_bdc_te1550_270  N$301 N$302 N$303 N$300 ebeam_bdc_te1550 library="Design kits/ebeam"  lay_x=235.375E-6 lay_y=862.35E-6 sch_x=6.819691215E0 sch_y=24.985494293E0  sch_r=180
 wg_heater_271  wg_heater_271_elec1 wg_heater_271_elec2 N$304 N$305 wg_heater library="Design kits/EBeam" wg_length=120.000u lay_x=355.9E-6 lay_y=882.35E-6 sch_x=10.311749776E0 sch_y=25.564968852E0  sch_r=180
 ebeam_terminator_te1550_272  N$297 ebeam_terminator_te1550 library="Design kits/ebeam"  lay_x=516.8E-6 lay_y=864.7E-6 sch_x=14.973622602E0 sch_y=25.053582554E0  sch_r=180
 ebeam_terminator_te1550_273  N$300 ebeam_terminator_te1550 library="Design kits/ebeam"  lay_x=194.55E-6 lay_y=864.7E-6 sch_x=5.636838772E0 sch_y=25.053582554E0
 ebeam_wg_integral_1550_274  N$298 N$301 ebeam_wg_integral_1550 library="Design kits/EBeam" wg_length=0.000198943 wg_width=5e-07 points="[[440.6,860.0],[430.6,860.0],[430.6,842.35],[280.75,842.35],[280.75,860.0],[270.75,860.0]]" radius=5e-06 lay_x=355.675E-6 lay_y=851.175E-6 sch_x=10.305230687E0 sch_y=24.661712884E0
 ebeam_wg_integral_1550_275  N$299 N$304 ebeam_wg_integral_1550 library="Design kits/EBeam" wg_length=0.000039247 wg_width=5e-07 points="[[440.6,864.7],[430.6,864.7],[430.6,882.35],[415.9,882.35]]" radius=5e-06 lay_x=428.25E-6 lay_y=873.525E-6 sch_x=12.407998992E0 sch_y=25.309275703E0
 ebeam_wg_integral_1550_276  N$305 N$302 ebeam_wg_integral_1550 library="Design kits/EBeam" wg_length=0.000039697 wg_width=5e-07 points="[[295.9,882.35],[280.75,882.35],[280.75,864.7],[270.75,864.7]]" radius=5e-06 lay_x=283.325E-6 lay_y=873.525E-6 sch_x=8.20898147E0 sch_y=25.309275703E0
 ebeam_wg_integral_1550_277  N$286 N$303 ebeam_wg_integral_1550 library="Design kits/EBeam" wg_length=0.000080000 wg_width=5e-07 points="[[120.0,860.0],[200.0,860.0]]" radius=5e-06 lay_x=160.0E-6 lay_y=860.0E-6 sch_x=4.635796471E0 sch_y=24.917406033E0
 ebeam_y_1550_278  N$273 N$276 N$275 ebeam_y_1550 library="Design kits/ebeam"  lay_x=581.35E-6 lay_y=1.054E-3 sch_x=16.843876741E0 sch_y=30.538309254E0
 ebeam_y_1550_279  N$277 N$282 N$279 ebeam_y_1550 library="Design kits/ebeam"  lay_x=671.35E-6 lay_y=1.05675E-3 sch_x=19.451512256E0 sch_y=30.617987006E0
.ends EBeam_heaters_atharvdubey_ALU4

EBeam_heaters_atharvdubey_ALU4  wg_heater_228_elec1 wg_heater_228_elec2 wg_heater_231_elec1 wg_heater_231_elec2 wg_heater_243_elec1 wg_heater_243_elec2 wg_heater_262_elec1 wg_heater_262_elec2 wg_heater_271_elec1 wg_heater_271_elec2  GC_TE_1550_8degOxide_BB_detector3 GC_TE_1550_8degOxide_BB_detector2 GC_TE_1550_8degOxide_BB_laser GC_TE_1550_8degOxide_BB_detector1 EBeam_heaters_atharvdubey_ALU4 sch_x=-1 sch_y=-1 sch_r=270
