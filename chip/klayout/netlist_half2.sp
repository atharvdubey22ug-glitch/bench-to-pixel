* Spice output from KLayout SiEPIC-Tools v0.5.31, 2026-10-15 10:03:15.

.subckt EBeam_heaters_atharvdubey_FullAdder wg_heater_68_elec1 wg_heater_68_elec2 wg_heater_90_elec1 wg_heater_90_elec2 wg_heater_91_elec1 wg_heater_91_elec2 wg_heater_103_elec1 wg_heater_103_elec2 wg_heater_110_elec1 wg_heater_110_elec2 GC_TE_1550_8degOxide_BB_detector3 GC_TE_1550_8degOxide_BB_detector2 GC_TE_1550_8degOxide_BB_laser GC_TE_1550_8degOxide_BB_detector1
.param MC_uniformity_width=0
.param MC_uniformity_thickness=0
.param MC_resolution_x=100
.param MC_resolution_y=100
.param MC_grid=10e-6
.param MC_non_uniform=0
 ebeam_wg_integral_1550_2  N$4 N$5 ebeam_wg_integral_1550 library="Design kits/EBeam" wg_length=0.000124247 wg_width=5e-07 points="[[864.05,357.65],[906.4,357.65],[906.4,315.0],[948.75,315.0]]" radius=5e-06 lay_x=906.4E-6 lay_y=336.325E-6 sch_x=26.261787009E0 sch_y=9.744589051E0
 ebeam_wg_integral_1550_3  N$6 N$7 ebeam_wg_integral_1550 library="Design kits/EBeam" wg_length=0.000640597 wg_width=5e-07 points="[[864.05,362.35],[890.05,362.35],[890.05,420.0],[1450.1,420.0]]" radius=5e-06 lay_x=1.157075E-3 lay_y=391.175E-6 sch_x=33.524776262E0 sch_y=11.333798029E0
 ebeam_terminator_te1550_60  N$66 ebeam_terminator_te1550 library="Design kits/ebeam"  lay_x=516.8E-6 lay_y=229.7E-6 sch_x=14.973622602E0 sch_y=6.655265309E0  sch_r=180
 ebeam_terminator_te1550_61  N$67 ebeam_terminator_te1550 library="Design kits/ebeam"  lay_x=194.55E-6 lay_y=229.7E-6 sch_x=5.636838772E0 sch_y=6.655265309E0
 ebeam_wg_integral_1550_62  N$68 N$69 ebeam_wg_integral_1550 library="Design kits/EBeam" wg_length=0.000198943 wg_width=5e-07 points="[[440.6,225.0],[430.6,225.0],[430.6,207.35],[280.75,207.35],[280.75,225.0],[270.75,225.0]]" radius=5e-06 lay_x=355.675E-6 lay_y=216.175E-6 sch_x=10.305230687E0 sch_y=6.263395638E0
 ebeam_wg_integral_1550_63  N$70 N$71 ebeam_wg_integral_1550 library="Design kits/EBeam" wg_length=0.000039247 wg_width=5e-07 points="[[440.6,229.7],[430.6,229.7],[430.6,247.35],[415.9,247.35]]" radius=5e-06 lay_x=428.25E-6 lay_y=238.525E-6 sch_x=12.407998992E0 sch_y=6.910958458E0
 ebeam_wg_integral_1550_64  N$73 N$72 ebeam_wg_integral_1550 library="Design kits/EBeam" wg_length=0.000039697 wg_width=5e-07 points="[[295.9,247.35],[280.75,247.35],[280.75,229.7],[270.75,229.7]]" radius=5e-06 lay_x=283.325E-6 lay_y=238.525E-6 sch_x=8.20898147E0 sch_y=6.910958458E0
 ebeam_wg_integral_1550_65  N$74 N$75 ebeam_wg_integral_1550 library="Design kits/EBeam" wg_length=0.000080000 wg_width=5e-07 points="[[120.0,225.0],[200.0,225.0]]" radius=5e-06 lay_x=160.0E-6 lay_y=225.0E-6 sch_x=4.635796471E0 sch_y=6.519088788E0
 ebeam_bdc_te1550_66  N$79 N$76 N$77 N$78 ebeam_bdc_te1550 library="Design kits/ebeam"  lay_x=475.975E-6 lay_y=100.35E-6 sch_x=13.790770159E0 sch_y=2.907513599E0  sch_r=180
 ebeam_bdc_te1550_67  N$81 N$82 N$83 N$80 ebeam_bdc_te1550 library="Design kits/ebeam"  lay_x=235.375E-6 lay_y=100.35E-6 sch_x=6.819691215E0 sch_y=2.907513599E0  sch_r=180
 wg_heater_68  wg_heater_68_elec1 wg_heater_68_elec2 N$84 N$85 wg_heater library="Design kits/EBeam" wg_length=120.000u lay_x=355.9E-6 lay_y=120.35E-6 sch_x=10.311749776E0 sch_y=3.486988158E0  sch_r=180
 ebeam_terminator_te1550_69  N$76 ebeam_terminator_te1550 library="Design kits/ebeam"  lay_x=516.8E-6 lay_y=102.7E-6 sch_x=14.973622602E0 sch_y=2.97560186E0  sch_r=180
 ebeam_terminator_te1550_70  N$80 ebeam_terminator_te1550 library="Design kits/ebeam"  lay_x=194.55E-6 lay_y=102.7E-6 sch_x=5.636838772E0 sch_y=2.97560186E0
 ebeam_wg_integral_1550_71  N$77 N$81 ebeam_wg_integral_1550 library="Design kits/EBeam" wg_length=0.000198943 wg_width=5e-07 points="[[440.6,98.0],[430.6,98.0],[430.6,80.35],[280.75,80.35],[280.75,98.0],[270.75,98.0]]" radius=5e-06 lay_x=355.675E-6 lay_y=89.175E-6 sch_x=10.305230687E0 sch_y=2.583732189E0
 ebeam_wg_integral_1550_72  N$78 N$84 ebeam_wg_integral_1550 library="Design kits/EBeam" wg_length=0.000039247 wg_width=5e-07 points="[[440.6,102.7],[430.6,102.7],[430.6,120.35],[415.9,120.35]]" radius=5e-06 lay_x=428.25E-6 lay_y=111.525E-6 sch_x=12.407998992E0 sch_y=3.231295009E0
 ebeam_wg_integral_1550_73  N$85 N$82 ebeam_wg_integral_1550 library="Design kits/EBeam" wg_length=0.000039697 wg_width=5e-07 points="[[295.9,120.35],[280.75,120.35],[280.75,102.7],[270.75,102.7]]" radius=5e-06 lay_x=283.325E-6 lay_y=111.525E-6 sch_x=8.20898147E0 sch_y=3.231295009E0
 ebeam_wg_integral_1550_74  N$86 N$83 ebeam_wg_integral_1550 library="Design kits/EBeam" wg_length=0.000080000 wg_width=5e-07 points="[[120.0,98.0],[200.0,98.0]]" radius=5e-06 lay_x=160.0E-6 lay_y=98.0E-6 sch_x=4.635796471E0 sch_y=2.839425339E0
 ebeam_y_1550_75  N$87 N$89 N$88 ebeam_y_1550 library="Design kits/ebeam"  lay_x=581.35E-6 lay_y=292.0E-6 sch_x=16.843876741E0 sch_y=8.46032856E0
 ebeam_y_1550_76  N$90 N$92 N$91 ebeam_y_1550 library="Design kits/ebeam"  lay_x=671.35E-6 lay_y=294.75E-6 sch_x=19.451512256E0 sch_y=8.540006312E0
 ebeam_wg_integral_1550_77  N$93 N$87 ebeam_wg_integral_1550 library="Design kits/EBeam" wg_length=0.000510847 wg_width=5e-07 points="[[120.0,352.0],[543.95,352.0],[543.95,292.0],[573.95,292.0]]" radius=5e-06 lay_x=346.975E-6 lay_y=322.0E-6 sch_x=10.053159254E0 sch_y=9.329540398E0
 ebeam_wg_integral_1550_78  N$88 N$94 ebeam_wg_integral_1550 library="Design kits/EBeam" wg_length=0.000158547 wg_width=5e-07 points="[[588.75,289.25],[598.75,289.25],[598.75,225.0],[511.35,225.0]]" radius=5e-06 lay_x=555.425E-6 lay_y=257.125E-6 sch_x=16.092732844E0 sch_y=7.449869798E0
 ebeam_wg_integral_1550_79  N$89 N$90 ebeam_wg_integral_1550 library="Design kits/EBeam" wg_length=0.000075200 wg_width=5e-07 points="[[588.75,294.75],[663.95,294.75]]" radius=5e-06 lay_x=626.35E-6 lay_y=294.75E-6 sch_x=18.147694498E0 sch_y=8.540006312E0
 ebeam_wg_integral_1550_80  N$91 N$79 ebeam_wg_integral_1550 library="Design kits/EBeam" wg_length=0.000378297 wg_width=5e-07 points="[[678.75,292.0],[688.75,292.0],[688.75,98.0],[511.35,98.0]]" radius=5e-06 lay_x=600.425E-6 lay_y=195.0E-6 sch_x=17.396550601E0 sch_y=5.649876949E0
 ebeam_bdc_te1550_81  N$95 N$96 N$4 N$6 ebeam_bdc_te1550 library="Design kits/ebeam"  lay_x=828.675E-6 lay_y=360.0E-6 sch_x=24.009804005E0 sch_y=10.43054206E0  sch_r=180 sch_f=true
 ebeam_wg_integral_1550_82  N$92 N$95 ebeam_wg_integral_1550 library="Design kits/EBeam" wg_length=0.000171597 wg_width=5e-07 points="[[678.75,297.5],[753.3,297.5],[753.3,357.65],[793.3,357.65]]" radius=5e-06 lay_x=736.025E-6 lay_y=327.575E-6 sch_x=21.325388111E0 sch_y=9.491068932E0
 ebeam_wg_integral_1550_83  N$96 N$97 ebeam_wg_integral_1550 library="Design kits/EBeam" wg_length=0.000786847 wg_width=5e-07 points="[[793.3,362.35],[781.3,362.35],[781.3,479.0],[120.0,479.0]]" radius=5e-06 lay_x=456.65E-6 lay_y=420.675E-6 sch_x=13.230852866E0 sch_y=12.188523003E0
 GC_TE_1550_8degOxide_BB_84  GC_TE_1550_8degOxide_BB_detector3 N$86 GC_TE_1550_8degOxide_BB library="Design kits/ebeam"  lay_x=100.015E-6 lay_y=98.084E-6 sch_x=2.8978074E0 sch_y=2.841859132E0
 GC_TE_1550_8degOxide_BB_85  GC_TE_1550_8degOxide_BB_detector2 N$74 GC_TE_1550_8degOxide_BB library="Design kits/ebeam"  lay_x=100.015E-6 lay_y=225.084E-6 sch_x=2.8978074E0 sch_y=6.521522581E0
 GC_TE_1550_8degOxide_BB_86  GC_TE_1550_8degOxide_BB_laser N$93 GC_TE_1550_8degOxide_BB library="Design kits/ebeam"  lay_x=100.015E-6 lay_y=352.084E-6 sch_x=2.8978074E0 sch_y=10.20118603E0
 GC_TE_1550_8degOxide_BB_87  GC_TE_1550_8degOxide_BB_detector1 N$97 GC_TE_1550_8degOxide_BB library="Design kits/ebeam"  lay_x=100.015E-6 lay_y=479.084E-6 sch_x=2.8978074E0 sch_y=13.880849479E0
 ebeam_bdc_te1550_88  N$94 N$66 N$68 N$70 ebeam_bdc_te1550 library="Design kits/ebeam"  lay_x=475.975E-6 lay_y=227.35E-6 sch_x=13.790770159E0 sch_y=6.587177048E0  sch_r=180
 ebeam_bdc_te1550_89  N$69 N$72 N$75 N$67 ebeam_bdc_te1550 library="Design kits/ebeam"  lay_x=235.375E-6 lay_y=227.35E-6 sch_x=6.819691215E0 sch_y=6.587177048E0  sch_r=180
 wg_heater_90  wg_heater_90_elec1 wg_heater_90_elec2 N$71 N$73 wg_heater library="Design kits/EBeam" wg_length=120.000u lay_x=355.9E-6 lay_y=247.35E-6 sch_x=10.311749776E0 sch_y=7.166651607E0  sch_r=180
 wg_heater_91  wg_heater_91_elec1 wg_heater_91_elec2 N$98 N$99 wg_heater library="Design kits/EBeam" wg_length=120.000u lay_x=1.60555E-3 lay_y=442.35E-6 sch_x=46.518768902E0 sch_y=12.816528556E0  sch_r=180 sch_f=true
 ebeam_terminator_te1550_92  N$100 ebeam_terminator_te1550 library="Design kits/ebeam"  lay_x=1.44465E-3 lay_y=424.7E-6 sch_x=41.856896076E0 sch_y=12.305142258E0  sch_r=180 sch_f=true
 ebeam_terminator_te1550_93  N$101 ebeam_terminator_te1550 library="Design kits/ebeam"  lay_x=1.7669E-3 lay_y=424.7E-6 sch_x=51.193679906E0 sch_y=12.305142258E0  sch_f=true
 ebeam_wg_integral_1550_94  N$102 N$103 ebeam_wg_integral_1550 library="Design kits/EBeam" wg_length=0.000198943 wg_width=5e-07 points="[[1520.85,420.0],[1530.85,420.0],[1530.85,402.35],[1680.7,402.35],[1680.7,420.0],[1690.7,420.0]]" radius=5e-06 lay_x=1.605775E-3 lay_y=411.175E-6 sch_x=46.525287991E0 sch_y=11.913272588E0
 ebeam_wg_integral_1550_95  N$104 N$98 ebeam_wg_integral_1550 library="Design kits/EBeam" wg_length=0.000039247 wg_width=5e-07 points="[[1520.85,424.7],[1530.85,424.7],[1530.85,442.35],[1545.55,442.35]]" radius=5e-06 lay_x=1.5332E-3 lay_y=433.525E-6 sch_x=44.422519685E0 sch_y=12.560835407E0
 ebeam_wg_integral_1550_96  N$99 N$105 ebeam_wg_integral_1550 library="Design kits/EBeam" wg_length=0.000039697 wg_width=5e-07 points="[[1665.55,442.35],[1680.7,442.35],[1680.7,424.7],[1690.7,424.7]]" radius=5e-06 lay_x=1.678125E-3 lay_y=433.525E-6 sch_x=48.621537208E0 sch_y=12.560835407E0
 ebeam_bdc_te1550_97  N$107 N$108 N$109 N$106 ebeam_bdc_te1550 library="Design kits/ebeam"  lay_x=1.224725E-3 lay_y=317.35E-6 sch_x=35.484848957E0 sch_y=9.194812563E0  sch_r=180 sch_f=true
 ebeam_y_1550_98  N$112 N$110 N$111 ebeam_y_1550 library="Design kits/ebeam"  lay_x=1.76885E-3 lay_y=420.0E-6 sch_x=51.250178675E0 sch_y=12.168965737E0
 ebeam_wg_integral_1550_99  N$110 N$111 ebeam_wg_integral_1550 library="Design kits/EBeam" wg_length=0.000120390 wg_width=5e-07 points="[[1776.25,422.75],[1788.85,422.75],[1788.85,435.0],[1813.85,435.0],[1813.85,405.0],[1788.85,405.0],[1788.85,417.25],[1776.25,417.25]]" radius=5e-06 lay_x=1.795425E-3 lay_y=420.0E-6 sch_x=52.020155496E0 sch_y=12.168965737E0
 ebeam_wg_integral_1550_100  N$114 N$113 ebeam_wg_integral_1550 library="Design kits/EBeam" wg_length=0.000396350 wg_width=5e-07 points="[[1380.1,315.0],[1776.45,315.0]]" radius=5e-06 lay_x=1.578275E-3 lay_y=315.0E-6 sch_x=45.728510472E0 sch_y=9.126724303E0
 ebeam_y_1550_101  N$113 N$115 N$116 ebeam_y_1550 library="Design kits/ebeam"  lay_x=1.78385E-3 lay_y=315.0E-6 sch_x=51.684784595E0 sch_y=9.126724303E0
 ebeam_wg_integral_1550_102  N$115 N$116 ebeam_wg_integral_1550 library="Design kits/EBeam" wg_length=0.000120390 wg_width=5e-07 points="[[1791.25,317.75],[1803.85,317.75],[1803.85,330.0],[1828.85,330.0],[1828.85,300.0],[1803.85,300.0],[1803.85,312.25],[1791.25,312.25]]" radius=5e-06 lay_x=1.810425E-3 lay_y=315.0E-6 sch_x=52.454761415E0 sch_y=9.126724303E0
 wg_heater_103  wg_heater_103_elec1 wg_heater_103_elec2 N$117 N$118 wg_heater library="Design kits/EBeam" wg_length=120.000u lay_x=1.1042E-3 lay_y=337.35E-6 sch_x=31.992790397E0 sch_y=9.774287122E0  sch_r=180 sch_f=true
 ebeam_terminator_te1550_104  N$119 ebeam_terminator_te1550 library="Design kits/ebeam"  lay_x=943.3E-6 lay_y=319.7E-6 sch_x=27.33091757E0 sch_y=9.262900824E0  sch_r=180 sch_f=true
 ebeam_terminator_te1550_105  N$106 ebeam_terminator_te1550 library="Design kits/ebeam"  lay_x=1.26555E-3 lay_y=319.7E-6 sch_x=36.667701401E0 sch_y=9.262900824E0  sch_f=true
 ebeam_wg_integral_1550_106  N$120 N$107 ebeam_wg_integral_1550 library="Design kits/EBeam" wg_length=0.000198943 wg_width=5e-07 points="[[1019.5,315.0],[1029.5,315.0],[1029.5,297.35],[1179.35,297.35],[1179.35,315.0],[1189.35,315.0]]" radius=5e-06 lay_x=1.104425E-3 lay_y=306.175E-6 sch_x=31.999309486E0 sch_y=8.871031154E0
 ebeam_wg_integral_1550_107  N$121 N$117 ebeam_wg_integral_1550 library="Design kits/EBeam" wg_length=0.000039247 wg_width=5e-07 points="[[1019.5,319.7],[1029.5,319.7],[1029.5,337.35],[1044.2,337.35]]" radius=5e-06 lay_x=1.03185E-3 lay_y=328.525E-6 sch_x=29.89654118E0 sch_y=9.518593973E0
 ebeam_wg_integral_1550_108  N$118 N$108 ebeam_wg_integral_1550 library="Design kits/EBeam" wg_length=0.000039697 wg_width=5e-07 points="[[1164.2,337.35],[1179.35,337.35],[1179.35,319.7],[1189.35,319.7]]" radius=5e-06 lay_x=1.176775E-3 lay_y=328.525E-6 sch_x=34.095558702E0 sch_y=9.518593973E0
 ebeam_bdc_te1550_109  N$5 N$119 N$120 N$121 ebeam_bdc_te1550 library="Design kits/ebeam"  lay_x=984.125E-6 lay_y=317.35E-6 sch_x=28.513770014E0 sch_y=9.194812563E0  sch_r=180 sch_f=true
 wg_heater_110  wg_heater_110_elec1 wg_heater_110_elec2 N$109 N$114 wg_heater library="Design kits/EBeam" wg_length=120.000u lay_x=1.3201E-3 lay_y=315.0E-6 sch_x=38.24821826E0 sch_y=9.126724303E0
 ebeam_bdc_te1550_111  N$7 N$100 N$102 N$104 ebeam_bdc_te1550 library="Design kits/ebeam"  lay_x=1.485475E-3 lay_y=422.35E-6 sch_x=43.039748519E0 sch_y=12.237053998E0  sch_r=180 sch_f=true
 ebeam_bdc_te1550_112  N$103 N$105 N$112 N$101 ebeam_bdc_te1550 library="Design kits/ebeam"  lay_x=1.726075E-3 lay_y=422.35E-6 sch_x=50.010827463E0 sch_y=12.237053998E0  sch_r=180 sch_f=true
.ends EBeam_heaters_atharvdubey_FullAdder

EBeam_heaters_atharvdubey_FullAdder  wg_heater_68_elec1 wg_heater_68_elec2 wg_heater_90_elec1 wg_heater_90_elec2 wg_heater_91_elec1 wg_heater_91_elec2 wg_heater_103_elec1 wg_heater_103_elec2 wg_heater_110_elec1 wg_heater_110_elec2  GC_TE_1550_8degOxide_BB_detector3 GC_TE_1550_8degOxide_BB_detector2 GC_TE_1550_8degOxide_BB_laser GC_TE_1550_8degOxide_BB_detector1 EBeam_heaters_atharvdubey_FullAdder sch_x=-1 sch_y=-1 sch_r=270
