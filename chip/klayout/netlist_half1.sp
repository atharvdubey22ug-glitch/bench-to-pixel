* Spice output from KLayout SiEPIC-Tools v0.5.31, 2026-10-15 10:03:15.

.subckt EBeam_heaters_atharvdubey_FullAdder wg_heater_6_elec1 wg_heater_6_elec2 wg_heater_9_elec1 wg_heater_9_elec2 wg_heater_21_elec1 wg_heater_21_elec2 wg_heater_34_elec1 wg_heater_34_elec2 wg_heater_43_elec1 wg_heater_43_elec2 GC_TE_1550_8degOxide_BB_detector3 GC_TE_1550_8degOxide_BB_detector2 GC_TE_1550_8degOxide_BB_laser GC_TE_1550_8degOxide_BB_detector1
.param MC_uniformity_width=0
.param MC_uniformity_thickness=0
.param MC_resolution_x=100
.param MC_resolution_y=100
.param MC_grid=10e-6
.param MC_non_uniform=0
 ebeam_wg_integral_1550_0  N$1 N$0 ebeam_wg_integral_1550 library="Design kits/EBeam" wg_length=0.000124247 wg_width=5e-07 points="[[864.05,1119.65],[906.4,1119.65],[906.4,1077.0],[948.75,1077.0]]" radius=5e-06 lay_x=906.4E-6 lay_y=1.098325E-3 sch_x=26.261787009E0 sch_y=31.822569745E0
 ebeam_wg_integral_1550_1  N$3 N$2 ebeam_wg_integral_1550 library="Design kits/EBeam" wg_length=0.000640597 wg_width=5e-07 points="[[864.05,1124.35],[890.05,1124.35],[890.05,1182.0],[1450.1,1182.0]]" radius=5e-06 lay_x=1.157075E-3 lay_y=1.153175E-3 sch_x=33.524776262E0 sch_y=33.411778723E0
 ebeam_wg_integral_1550_4  N$9 N$8 ebeam_wg_integral_1550 library="Design kits/EBeam" wg_length=0.000039697 wg_width=5e-07 points="[[1164.2,1099.35],[1179.35,1099.35],[1179.35,1081.7],[1189.35,1081.7]]" radius=5e-06 lay_x=1.176775E-3 lay_y=1.090525E-3 sch_x=34.095558702E0 sch_y=31.596574667E0
 ebeam_bdc_te1550_5  N$0 N$10 N$11 N$12 ebeam_bdc_te1550 library="Design kits/ebeam"  lay_x=984.125E-6 lay_y=1.07935E-3 sch_x=28.513770014E0 sch_y=31.272793257E0  sch_r=180 sch_f=true
 wg_heater_6  wg_heater_6_elec1 wg_heater_6_elec2 N$13 N$14 wg_heater library="Design kits/EBeam" wg_length=120.000u lay_x=1.3201E-3 lay_y=1.077E-3 sch_x=38.24821826E0 sch_y=31.204704997E0
 ebeam_bdc_te1550_7  N$2 N$15 N$16 N$17 ebeam_bdc_te1550 library="Design kits/ebeam"  lay_x=1.485475E-3 lay_y=1.18435E-3 sch_x=43.039748519E0 sch_y=34.315034692E0  sch_r=180 sch_f=true
 ebeam_bdc_te1550_8  N$19 N$20 N$21 N$18 ebeam_bdc_te1550 library="Design kits/ebeam"  lay_x=1.726075E-3 lay_y=1.18435E-3 sch_x=50.010827463E0 sch_y=34.315034692E0  sch_r=180 sch_f=true
 wg_heater_9  wg_heater_9_elec1 wg_heater_9_elec2 N$22 N$23 wg_heater library="Design kits/EBeam" wg_length=120.000u lay_x=1.60555E-3 lay_y=1.20435E-3 sch_x=46.518768902E0 sch_y=34.89450925E0  sch_r=180 sch_f=true
 ebeam_terminator_te1550_10  N$15 ebeam_terminator_te1550 library="Design kits/ebeam"  lay_x=1.44465E-3 lay_y=1.1867E-3 sch_x=41.856896076E0 sch_y=34.383122952E0  sch_r=180 sch_f=true
 ebeam_terminator_te1550_11  N$18 ebeam_terminator_te1550 library="Design kits/ebeam"  lay_x=1.7669E-3 lay_y=1.1867E-3 sch_x=51.193679906E0 sch_y=34.383122952E0  sch_f=true
 ebeam_wg_integral_1550_12  N$16 N$19 ebeam_wg_integral_1550 library="Design kits/EBeam" wg_length=0.000198943 wg_width=5e-07 points="[[1520.85,1182.0],[1530.85,1182.0],[1530.85,1164.35],[1680.7,1164.35],[1680.7,1182.0],[1690.7,1182.0]]" radius=5e-06 lay_x=1.605775E-3 lay_y=1.173175E-3 sch_x=46.525287991E0 sch_y=33.991253282E0
 ebeam_wg_integral_1550_13  N$17 N$22 ebeam_wg_integral_1550 library="Design kits/EBeam" wg_length=0.000039247 wg_width=5e-07 points="[[1520.85,1186.7],[1530.85,1186.7],[1530.85,1204.35],[1545.55,1204.35]]" radius=5e-06 lay_x=1.5332E-3 lay_y=1.195525E-3 sch_x=44.422519685E0 sch_y=34.638816101E0
 ebeam_wg_integral_1550_14  N$23 N$20 ebeam_wg_integral_1550 library="Design kits/EBeam" wg_length=0.000039697 wg_width=5e-07 points="[[1665.55,1204.35],[1680.7,1204.35],[1680.7,1186.7],[1690.7,1186.7]]" radius=5e-06 lay_x=1.678125E-3 lay_y=1.195525E-3 sch_x=48.621537208E0 sch_y=34.638816101E0
 ebeam_bdc_te1550_15  N$25 N$8 N$13 N$24 ebeam_bdc_te1550 library="Design kits/ebeam"  lay_x=1.224725E-3 lay_y=1.07935E-3 sch_x=35.484848957E0 sch_y=31.272793257E0  sch_r=180 sch_f=true
 ebeam_y_1550_16  N$21 N$26 N$27 ebeam_y_1550 library="Design kits/ebeam"  lay_x=1.76885E-3 lay_y=1.182E-3 sch_x=51.250178675E0 sch_y=34.246946431E0
 ebeam_wg_integral_1550_17  N$26 N$27 ebeam_wg_integral_1550 library="Design kits/EBeam" wg_length=0.000120390 wg_width=5e-07 points="[[1776.25,1184.75],[1788.85,1184.75],[1788.85,1197.0],[1813.85,1197.0],[1813.85,1167.0],[1788.85,1167.0],[1788.85,1179.25],[1776.25,1179.25]]" radius=5e-06 lay_x=1.795425E-3 lay_y=1.182E-3 sch_x=52.020155496E0 sch_y=34.246946431E0
 ebeam_wg_integral_1550_18  N$14 N$28 ebeam_wg_integral_1550 library="Design kits/EBeam" wg_length=0.000396350 wg_width=5e-07 points="[[1380.1,1077.0],[1776.45,1077.0]]" radius=5e-06 lay_x=1.578275E-3 lay_y=1.077E-3 sch_x=45.728510472E0 sch_y=31.204704997E0
 ebeam_y_1550_19  N$28 N$29 N$30 ebeam_y_1550 library="Design kits/ebeam"  lay_x=1.78385E-3 lay_y=1.077E-3 sch_x=51.684784595E0 sch_y=31.204704997E0
 ebeam_wg_integral_1550_20  N$29 N$30 ebeam_wg_integral_1550 library="Design kits/EBeam" wg_length=0.000120390 wg_width=5e-07 points="[[1791.25,1079.75],[1803.85,1079.75],[1803.85,1092.0],[1828.85,1092.0],[1828.85,1062.0],[1803.85,1062.0],[1803.85,1074.25],[1791.25,1074.25]]" radius=5e-06 lay_x=1.810425E-3 lay_y=1.077E-3 sch_x=52.454761415E0 sch_y=31.204704997E0
 wg_heater_21  wg_heater_21_elec1 wg_heater_21_elec2 N$31 N$9 wg_heater library="Design kits/EBeam" wg_length=120.000u lay_x=1.1042E-3 lay_y=1.09935E-3 sch_x=31.992790397E0 sch_y=31.852267816E0  sch_r=180 sch_f=true
 ebeam_terminator_te1550_22  N$10 ebeam_terminator_te1550 library="Design kits/ebeam"  lay_x=943.3E-6 lay_y=1.0817E-3 sch_x=27.33091757E0 sch_y=31.340881518E0  sch_r=180 sch_f=true
 ebeam_terminator_te1550_23  N$24 ebeam_terminator_te1550 library="Design kits/ebeam"  lay_x=1.26555E-3 lay_y=1.0817E-3 sch_x=36.667701401E0 sch_y=31.340881518E0  sch_f=true
 ebeam_wg_integral_1550_24  N$11 N$25 ebeam_wg_integral_1550 library="Design kits/EBeam" wg_length=0.000198943 wg_width=5e-07 points="[[1019.5,1077.0],[1029.5,1077.0],[1029.5,1059.35],[1179.35,1059.35],[1179.35,1077.0],[1189.35,1077.0]]" radius=5e-06 lay_x=1.104425E-3 lay_y=1.068175E-3 sch_x=31.999309486E0 sch_y=30.949011848E0
 ebeam_wg_integral_1550_25  N$12 N$31 ebeam_wg_integral_1550 library="Design kits/EBeam" wg_length=0.000039247 wg_width=5e-07 points="[[1019.5,1081.7],[1029.5,1081.7],[1029.5,1099.35],[1044.2,1099.35]]" radius=5e-06 lay_x=1.03185E-3 lay_y=1.090525E-3 sch_x=29.89654118E0 sch_y=31.596574667E0
 ebeam_wg_integral_1550_26  N$32 N$33 ebeam_wg_integral_1550 library="Design kits/EBeam" wg_length=0.000171597 wg_width=5e-07 points="[[678.75,1059.5],[753.3,1059.5],[753.3,1119.65],[793.3,1119.65]]" radius=5e-06 lay_x=736.025E-6 lay_y=1.089575E-3 sch_x=21.325388111E0 sch_y=31.569049626E0
 ebeam_wg_integral_1550_27  N$35 N$34 ebeam_wg_integral_1550 library="Design kits/EBeam" wg_length=0.000786847 wg_width=5e-07 points="[[793.3,1124.35],[781.3,1124.35],[781.3,1241.0],[120.0,1241.0]]" radius=5e-06 lay_x=456.65E-6 lay_y=1.182675E-3 sch_x=13.230852866E0 sch_y=34.266503697E0
 GC_TE_1550_8degOxide_BB_28  GC_TE_1550_8degOxide_BB_detector3 N$36 GC_TE_1550_8degOxide_BB library="Design kits/ebeam"  lay_x=100.015E-6 lay_y=860.084E-6 sch_x=2.8978074E0 sch_y=24.919839826E0
 GC_TE_1550_8degOxide_BB_29  GC_TE_1550_8degOxide_BB_detector2 N$37 GC_TE_1550_8degOxide_BB library="Design kits/ebeam"  lay_x=100.015E-6 lay_y=987.084E-6 sch_x=2.8978074E0 sch_y=28.599503275E0
 GC_TE_1550_8degOxide_BB_30  GC_TE_1550_8degOxide_BB_laser N$38 GC_TE_1550_8degOxide_BB library="Design kits/ebeam"  lay_x=100.015E-6 lay_y=1.114084E-3 sch_x=2.8978074E0 sch_y=32.279166724E0
 GC_TE_1550_8degOxide_BB_31  GC_TE_1550_8degOxide_BB_detector1 N$34 GC_TE_1550_8degOxide_BB library="Design kits/ebeam"  lay_x=100.015E-6 lay_y=1.241084E-3 sch_x=2.8978074E0 sch_y=35.958830173E0
 ebeam_bdc_te1550_32  N$42 N$39 N$40 N$41 ebeam_bdc_te1550 library="Design kits/ebeam"  lay_x=475.975E-6 lay_y=989.35E-6 sch_x=13.790770159E0 sch_y=28.665157742E0  sch_r=180
 ebeam_bdc_te1550_33  N$44 N$45 N$46 N$43 ebeam_bdc_te1550 library="Design kits/ebeam"  lay_x=235.375E-6 lay_y=989.35E-6 sch_x=6.819691215E0 sch_y=28.665157742E0  sch_r=180
 wg_heater_34  wg_heater_34_elec1 wg_heater_34_elec2 N$47 N$48 wg_heater library="Design kits/EBeam" wg_length=120.000u lay_x=355.9E-6 lay_y=1.00935E-3 sch_x=10.311749776E0 sch_y=29.244632301E0  sch_r=180
 ebeam_terminator_te1550_35  N$39 ebeam_terminator_te1550 library="Design kits/ebeam"  lay_x=516.8E-6 lay_y=991.7E-6 sch_x=14.973622602E0 sch_y=28.733246003E0  sch_r=180
 ebeam_terminator_te1550_36  N$43 ebeam_terminator_te1550 library="Design kits/ebeam"  lay_x=194.55E-6 lay_y=991.7E-6 sch_x=5.636838772E0 sch_y=28.733246003E0
 ebeam_wg_integral_1550_37  N$40 N$44 ebeam_wg_integral_1550 library="Design kits/EBeam" wg_length=0.000198943 wg_width=5e-07 points="[[440.6,987.0],[430.6,987.0],[430.6,969.35],[280.75,969.35],[280.75,987.0],[270.75,987.0]]" radius=5e-06 lay_x=355.675E-6 lay_y=978.175E-6 sch_x=10.305230687E0 sch_y=28.341376333E0
 ebeam_wg_integral_1550_38  N$41 N$47 ebeam_wg_integral_1550 library="Design kits/EBeam" wg_length=0.000039247 wg_width=5e-07 points="[[440.6,991.7],[430.6,991.7],[430.6,1009.35],[415.9,1009.35]]" radius=5e-06 lay_x=428.25E-6 lay_y=1.000525E-3 sch_x=12.407998992E0 sch_y=28.988939152E0
 ebeam_wg_integral_1550_39  N$48 N$45 ebeam_wg_integral_1550 library="Design kits/EBeam" wg_length=0.000039697 wg_width=5e-07 points="[[295.9,1009.35],[280.75,1009.35],[280.75,991.7],[270.75,991.7]]" radius=5e-06 lay_x=283.325E-6 lay_y=1.000525E-3 sch_x=8.20898147E0 sch_y=28.988939152E0
 ebeam_wg_integral_1550_40  N$37 N$46 ebeam_wg_integral_1550 library="Design kits/EBeam" wg_length=0.000080000 wg_width=5e-07 points="[[120.0,987.0],[200.0,987.0]]" radius=5e-06 lay_x=160.0E-6 lay_y=987.0E-6 sch_x=4.635796471E0 sch_y=28.597069482E0
 ebeam_bdc_te1550_41  N$52 N$49 N$50 N$51 ebeam_bdc_te1550 library="Design kits/ebeam"  lay_x=475.975E-6 lay_y=862.35E-6 sch_x=13.790770159E0 sch_y=24.985494293E0  sch_r=180
 ebeam_bdc_te1550_42  N$54 N$55 N$56 N$53 ebeam_bdc_te1550 library="Design kits/ebeam"  lay_x=235.375E-6 lay_y=862.35E-6 sch_x=6.819691215E0 sch_y=24.985494293E0  sch_r=180
 wg_heater_43  wg_heater_43_elec1 wg_heater_43_elec2 N$57 N$58 wg_heater library="Design kits/EBeam" wg_length=120.000u lay_x=355.9E-6 lay_y=882.35E-6 sch_x=10.311749776E0 sch_y=25.564968852E0  sch_r=180
 ebeam_terminator_te1550_44  N$49 ebeam_terminator_te1550 library="Design kits/ebeam"  lay_x=516.8E-6 lay_y=864.7E-6 sch_x=14.973622602E0 sch_y=25.053582554E0  sch_r=180
 ebeam_terminator_te1550_45  N$53 ebeam_terminator_te1550 library="Design kits/ebeam"  lay_x=194.55E-6 lay_y=864.7E-6 sch_x=5.636838772E0 sch_y=25.053582554E0
 ebeam_wg_integral_1550_46  N$50 N$54 ebeam_wg_integral_1550 library="Design kits/EBeam" wg_length=0.000198943 wg_width=5e-07 points="[[440.6,860.0],[430.6,860.0],[430.6,842.35],[280.75,842.35],[280.75,860.0],[270.75,860.0]]" radius=5e-06 lay_x=355.675E-6 lay_y=851.175E-6 sch_x=10.305230687E0 sch_y=24.661712884E0
 ebeam_wg_integral_1550_47  N$51 N$57 ebeam_wg_integral_1550 library="Design kits/EBeam" wg_length=0.000039247 wg_width=5e-07 points="[[440.6,864.7],[430.6,864.7],[430.6,882.35],[415.9,882.35]]" radius=5e-06 lay_x=428.25E-6 lay_y=873.525E-6 sch_x=12.407998992E0 sch_y=25.309275703E0
 ebeam_wg_integral_1550_48  N$58 N$55 ebeam_wg_integral_1550 library="Design kits/EBeam" wg_length=0.000039697 wg_width=5e-07 points="[[295.9,882.35],[280.75,882.35],[280.75,864.7],[270.75,864.7]]" radius=5e-06 lay_x=283.325E-6 lay_y=873.525E-6 sch_x=8.20898147E0 sch_y=25.309275703E0
 ebeam_wg_integral_1550_49  N$36 N$56 ebeam_wg_integral_1550 library="Design kits/EBeam" wg_length=0.000080000 wg_width=5e-07 points="[[120.0,860.0],[200.0,860.0]]" radius=5e-06 lay_x=160.0E-6 lay_y=860.0E-6 sch_x=4.635796471E0 sch_y=24.917406033E0
 ebeam_y_1550_50  N$59 N$61 N$60 ebeam_y_1550 library="Design kits/ebeam"  lay_x=581.35E-6 lay_y=1.054E-3 sch_x=16.843876741E0 sch_y=30.538309254E0
 ebeam_y_1550_51  N$62 N$32 N$63 ebeam_y_1550 library="Design kits/ebeam"  lay_x=671.35E-6 lay_y=1.05675E-3 sch_x=19.451512256E0 sch_y=30.617987006E0
 ebeam_wg_integral_1550_52  N$38 N$59 ebeam_wg_integral_1550 library="Design kits/EBeam" wg_length=0.000510847 wg_width=5e-07 points="[[120.0,1114.0],[543.95,1114.0],[543.95,1054.0],[573.95,1054.0]]" radius=5e-06 lay_x=346.975E-6 lay_y=1.084E-3 sch_x=10.053159254E0 sch_y=31.407521092E0
 ebeam_wg_integral_1550_53  N$60 N$42 ebeam_wg_integral_1550 library="Design kits/EBeam" wg_length=0.000158547 wg_width=5e-07 points="[[588.75,1051.25],[598.75,1051.25],[598.75,987.0],[511.35,987.0]]" radius=5e-06 lay_x=555.425E-6 lay_y=1.019125E-3 sch_x=16.092732844E0 sch_y=29.527850492E0
 ebeam_wg_integral_1550_54  N$61 N$62 ebeam_wg_integral_1550 library="Design kits/EBeam" wg_length=0.000075200 wg_width=5e-07 points="[[588.75,1056.75],[663.95,1056.75]]" radius=5e-06 lay_x=626.35E-6 lay_y=1.05675E-3 sch_x=18.147694498E0 sch_y=30.617987006E0
 ebeam_wg_integral_1550_55  N$63 N$52 ebeam_wg_integral_1550 library="Design kits/EBeam" wg_length=0.000378297 wg_width=5e-07 points="[[678.75,1054.0],[688.75,1054.0],[688.75,860.0],[511.35,860.0]]" radius=5e-06 lay_x=600.425E-6 lay_y=957.0E-6 sch_x=17.396550601E0 sch_y=27.727857643E0
 ebeam_bdc_te1550_59  N$33 N$35 N$1 N$3 ebeam_bdc_te1550 library="Design kits/ebeam"  lay_x=828.675E-6 lay_y=1.122E-3 sch_x=24.009804005E0 sch_y=32.508522754E0  sch_r=180 sch_f=true
.ends EBeam_heaters_atharvdubey_FullAdder

EBeam_heaters_atharvdubey_FullAdder  wg_heater_6_elec1 wg_heater_6_elec2 wg_heater_9_elec1 wg_heater_9_elec2 wg_heater_21_elec1 wg_heater_21_elec2 wg_heater_34_elec1 wg_heater_34_elec2 wg_heater_43_elec1 wg_heater_43_elec2  GC_TE_1550_8degOxide_BB_detector3 GC_TE_1550_8degOxide_BB_detector2 GC_TE_1550_8degOxide_BB_laser GC_TE_1550_8degOxide_BB_detector1 EBeam_heaters_atharvdubey_FullAdder sch_x=-1 sch_y=-1 sch_r=270
